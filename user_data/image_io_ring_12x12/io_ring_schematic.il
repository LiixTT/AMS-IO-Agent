cv = geGetWindowCellView()
pdb3ac_h_gMaster = dbOpenCellView("tphn28hpcpgv18" "PDB3AC_H_G" "symbol")
dbCreateInst(cv pdb3ac_h_gMaster "CS_left0" '(0 24.8125) "R270")
schCreateWire(cv "route" "full" '((0.000 25.000) (-0.750 25.000)) 0 0 0 nil nil)
schCreateWireLabel(cv nil '(-0.250 25.000) "CS" "lowerRight" "R0" "stick" 0.0625 nil)
schCreatePin(cv nil "CS" "inputOutput" nil '(-0.750 25.000) "R0")
schCreateWire(cv "route" "full" '((0.875 25.062) (1.625 25.062)) 0 0 0 nil nil)
schCreateWireLabel(cv nil '(1.125 25.062) "RVSS" "lowerLeft" "R0" "stick" 0.0625 nil)
schCreateWire(cv "route" "full" '((0.875 24.688) (1.625 24.688)) 0 0 0 nil nil)
schCreateWireLabel(cv nil '(1.125 24.688) "GIOL" "lowerLeft" "R0" "stick" 0.0625 nil)
schCreateWire(cv "route" "full" '((0.875 25.438) (1.625 25.438)) 0 0 0 nil nil)
schCreateWireLabel(cv nil '(1.125 25.438) "RVDDH" "lowerLeft" "R0" "stick" 0.0625 nil)
pvss1ac_h_gMaster = dbOpenCellView("tphn28hpcpgv18" "PVSS1AC_H_G" "symbol")
dbCreateInst(cv pvss1ac_h_gMaster "IOVSS_left1" '(0 22.8125) "R270")
schCreateWire(cv "route" "full" '((0.000 23.000) (-0.750 23.000)) 0 0 0 nil nil)
schCreateWireLabel(cv nil '(-0.250 23.000) "IOVSS" "lowerRight" "R0" "stick" 0.0625 nil)
schCreatePin(cv nil "IOVSS" "inputOutput" nil '(-0.750 23.000) "R0")
schCreateWire(cv "route" "full" '((0.875 23.062) (1.625 23.062)) 0 0 0 nil nil)
schCreateWireLabel(cv nil '(1.125 23.062) "RVSS" "lowerLeft" "R0" "stick" 0.0625 nil)
schCreateWire(cv "route" "full" '((0.875 22.688) (1.625 22.688)) 0 0 0 nil nil)
schCreateWireLabel(cv nil '(1.125 22.688) "GIOL" "lowerLeft" "R0" "stick" 0.0625 nil)
schCreateWire(cv "route" "full" '((0.875 23.438) (1.625 23.438)) 0 0 0 nil nil)
schCreateWireLabel(cv nil '(1.125 23.438) "RVDDH" "lowerLeft" "R0" "stick" 0.0625 nil)
dbCreateInst(cv pvss1ac_h_gMaster "VSS_left2" '(0 20.8125) "R270")
schCreateWire(cv "route" "full" '((0.000 21.000) (-0.750 21.000)) 0 0 0 nil nil)
schCreateWireLabel(cv nil '(-0.250 21.000) "VSS" "lowerRight" "R0" "stick" 0.0625 nil)
schCreatePin(cv nil "VSS" "inputOutput" nil '(-0.750 21.000) "R0")
schCreateWire(cv "route" "full" '((0.875 21.062) (1.625 21.062)) 0 0 0 nil nil)
schCreateWireLabel(cv nil '(1.125 21.062) "RVSS" "lowerLeft" "R0" "stick" 0.0625 nil)
schCreateWire(cv "route" "full" '((0.875 20.688) (1.625 20.688)) 0 0 0 nil nil)
schCreateWireLabel(cv nil '(1.125 20.688) "GIOL" "lowerLeft" "R0" "stick" 0.0625 nil)
schCreateWire(cv "route" "full" '((0.875 21.438) (1.625 21.438)) 0 0 0 nil nil)
schCreateWireLabel(cv nil '(1.125 21.438) "RVDDH" "lowerLeft" "R0" "stick" 0.0625 nil)
pvdd3ac_h_gMaster = dbOpenCellView("tphn28hpcpgv18" "PVDD3AC_H_G" "symbol")
dbCreateInst(cv pvdd3ac_h_gMaster "RVDDH_left3" '(0 18.8125) "R270")
schCreateWire(cv "route" "full" '((0.875 19.438) (1.625 19.438)) 0 0 0 nil nil)
schCreateWireLabel(cv nil '(1.125 19.438) "RVDDH_CORE" "lowerLeft" "R0" "stick" 0.0625 nil)
schCreatePin(cv nil "RVDDH_CORE" "inputOutput" nil '(1.625 19.438) "R180")
schCreateWire(cv "route" "full" '((0.875 19.062) (1.625 19.062)) 0 0 0 nil nil)
schCreateWireLabel(cv nil '(1.125 19.062) "RVSS" "lowerLeft" "R0" "stick" 0.0625 nil)
schCreateWire(cv "route" "full" '((0.875 18.688) (1.625 18.688)) 0 0 0 nil nil)
schCreateWireLabel(cv nil '(1.125 18.688) "GIOL" "lowerLeft" "R0" "stick" 0.0625 nil)
schCreateWire(cv "route" "full" '((0.000 19.000) (-0.750 19.000)) 0 0 0 nil nil)
schCreateWireLabel(cv nil '(-0.250 19.000) "RVDDH" "lowerRight" "R0" "stick" 0.0625 nil)
schCreatePin(cv nil "RVDDH" "inputOutput" nil '(-0.750 19.000) "R0")
pvdd1ac_h_gMaster = dbOpenCellView("tphn28hpcpgv18" "PVDD1AC_H_G" "symbol")
dbCreateInst(cv pvdd1ac_h_gMaster "RVDD_left4" '(0 16.8125) "R270")
schCreateWire(cv "route" "full" '((0.875 17.062) (1.625 17.062)) 0 0 0 nil nil)
schCreateWireLabel(cv nil '(1.125 17.062) "RVSS" "lowerLeft" "R0" "stick" 0.0625 nil)
schCreateWire(cv "route" "full" '((0.875 16.688) (1.625 16.688)) 0 0 0 nil nil)
schCreateWireLabel(cv nil '(1.125 16.688) "GIOL" "lowerLeft" "R0" "stick" 0.0625 nil)
schCreateWire(cv "route" "full" '((0.000 17.000) (-0.750 17.000)) 0 0 0 nil nil)
schCreateWireLabel(cv nil '(-0.250 17.000) "RVDD" "lowerRight" "R0" "stick" 0.0625 nil)
schCreatePin(cv nil "RVDD" "inputOutput" nil '(-0.750 17.000) "R0")
schCreateWire(cv "route" "full" '((0.875 17.438) (1.625 17.438)) 0 0 0 nil nil)
schCreateWireLabel(cv nil '(1.125 17.438) "RVDDH" "lowerLeft" "R0" "stick" 0.0625 nil)
dbCreateInst(cv pdb3ac_h_gMaster "IBIAS_REF_left5" '(0 14.8125) "R270")
schCreateWire(cv "route" "full" '((0.000 15.001) (-0.750 15.001)) 0 0 0 nil nil)
schCreateWireLabel(cv nil '(-0.250 15.001) "IBIAS_REF" "lowerRight" "R0" "stick" 0.0625 nil)
schCreatePin(cv nil "IBIAS_REF" "inputOutput" nil '(-0.750 15.001) "R0")
schCreateWire(cv "route" "full" '((0.875 15.062) (1.625 15.062)) 0 0 0 nil nil)
schCreateWireLabel(cv nil '(1.125 15.062) "RVSS" "lowerLeft" "R0" "stick" 0.0625 nil)
schCreateWire(cv "route" "full" '((0.875 14.688) (1.625 14.688)) 0 0 0 nil nil)
schCreateWireLabel(cv nil '(1.125 14.688) "GIOL" "lowerLeft" "R0" "stick" 0.0625 nil)
schCreateWire(cv "route" "full" '((0.875 15.438) (1.625 15.438)) 0 0 0 nil nil)
schCreateWireLabel(cv nil '(1.125 15.438) "RVDDH" "lowerLeft" "R0" "stick" 0.0625 nil)
dbCreateInst(cv pdb3ac_h_gMaster "VREFIN_left6" '(0 12.8125) "R270")
schCreateWire(cv "route" "full" '((0.000 13.001) (-0.750 13.001)) 0 0 0 nil nil)
schCreateWireLabel(cv nil '(-0.250 13.001) "VREFIN" "lowerRight" "R0" "stick" 0.0625 nil)
schCreatePin(cv nil "VREFIN" "inputOutput" nil '(-0.750 13.001) "R0")
schCreateWire(cv "route" "full" '((0.875 13.062) (1.625 13.062)) 0 0 0 nil nil)
schCreateWireLabel(cv nil '(1.125 13.062) "RVSS" "lowerLeft" "R0" "stick" 0.0625 nil)
schCreateWire(cv "route" "full" '((0.875 12.688) (1.625 12.688)) 0 0 0 nil nil)
schCreateWireLabel(cv nil '(1.125 12.688) "GIOL" "lowerLeft" "R0" "stick" 0.0625 nil)
schCreateWire(cv "route" "full" '((0.875 13.438) (1.625 13.438)) 0 0 0 nil nil)
schCreateWireLabel(cv nil '(1.125 13.438) "RVDDH" "lowerLeft" "R0" "stick" 0.0625 nil)
pvss3ac_h_gMaster = dbOpenCellView("tphn28hpcpgv18" "PVSS3AC_H_G" "symbol")
dbCreateInst(cv pvss3ac_h_gMaster "RVSS_left7" '(0 10.8125) "R270")
schCreateWire(cv "route" "full" '((0.000 11.001) (-0.750 11.001)) 0 0 0 nil nil)
schCreateWireLabel(cv nil '(-0.250 11.001) "RVSS" "lowerRight" "R0" "stick" 0.0625 nil)
schCreatePin(cv nil "RVSS" "inputOutput" nil '(-0.750 11.001) "R0")
schCreateWire(cv "route" "full" '((0.875 10.688) (1.625 10.688)) 0 0 0 nil nil)
schCreateWireLabel(cv nil '(1.125 10.688) "GIOL" "lowerLeft" "R0" "stick" 0.0625 nil)
schCreateWire(cv "route" "full" '((0.875 11.438) (1.625 11.438)) 0 0 0 nil nil)
schCreateWireLabel(cv nil '(1.125 11.438) "RVSS_CORE" "lowerLeft" "R0" "stick" 0.0625 nil)
schCreatePin(cv nil "RVSS_CORE" "inputOutput" nil '(1.625 11.438) "R180")
schCreateWire(cv "route" "full" '((0.875 11.062) (1.625 11.062)) 0 0 0 nil nil)
schCreateWireLabel(cv nil '(1.125 11.062) "RVDDH" "lowerLeft" "R0" "stick" 0.0625 nil)
dbCreateInst(cv pvdd1ac_h_gMaster "CKVDD_left8" '(0 8.8125) "R270")
schCreateWire(cv "route" "full" '((0.875 9.062) (1.625 9.062)) 0 0 0 nil nil)
schCreateWireLabel(cv nil '(1.125 9.062) "RVSS" "lowerLeft" "R0" "stick" 0.0625 nil)
schCreateWire(cv "route" "full" '((0.875 8.688) (1.625 8.688)) 0 0 0 nil nil)
schCreateWireLabel(cv nil '(1.125 8.688) "GIOL" "lowerLeft" "R0" "stick" 0.0625 nil)
schCreateWire(cv "route" "full" '((0.000 9.001) (-0.750 9.001)) 0 0 0 nil nil)
schCreateWireLabel(cv nil '(-0.250 9.001) "CKVDD" "lowerRight" "R0" "stick" 0.0625 nil)
schCreatePin(cv nil "CKVDD" "inputOutput" nil '(-0.750 9.001) "R0")
schCreateWire(cv "route" "full" '((0.875 9.438) (1.625 9.438)) 0 0 0 nil nil)
schCreateWireLabel(cv nil '(1.125 9.438) "RVDDH" "lowerLeft" "R0" "stick" 0.0625 nil)
dbCreateInst(cv pdb3ac_h_gMaster "CLKINP_left9" '(0 6.8125) "R270")
schCreateWire(cv "route" "full" '((0.000 7.000) (-0.750 7.000)) 0 0 0 nil nil)
schCreateWireLabel(cv nil '(-0.250 7.000) "CLKINP" "lowerRight" "R0" "stick" 0.0625 nil)
schCreatePin(cv nil "CLKINP" "inputOutput" nil '(-0.750 7.000) "R0")
schCreateWire(cv "route" "full" '((0.875 7.062) (1.625 7.062)) 0 0 0 nil nil)
schCreateWireLabel(cv nil '(1.125 7.062) "RVSS" "lowerLeft" "R0" "stick" 0.0625 nil)
schCreateWire(cv "route" "full" '((0.875 6.688) (1.625 6.688)) 0 0 0 nil nil)
schCreateWireLabel(cv nil '(1.125 6.688) "GIOL" "lowerLeft" "R0" "stick" 0.0625 nil)
schCreateWire(cv "route" "full" '((0.875 7.438) (1.625 7.438)) 0 0 0 nil nil)
schCreateWireLabel(cv nil '(1.125 7.438) "RVDDH" "lowerLeft" "R0" "stick" 0.0625 nil)
dbCreateInst(cv pdb3ac_h_gMaster "CLKINN_left10" '(0 4.8125) "R270")
schCreateWire(cv "route" "full" '((0.000 5.000) (-0.750 5.000)) 0 0 0 nil nil)
schCreateWireLabel(cv nil '(-0.250 5.000) "CLKINN" "lowerRight" "R0" "stick" 0.0625 nil)
schCreatePin(cv nil "CLKINN" "inputOutput" nil '(-0.750 5.000) "R0")
schCreateWire(cv "route" "full" '((0.875 5.062) (1.625 5.062)) 0 0 0 nil nil)
schCreateWireLabel(cv nil '(1.125 5.062) "RVSS" "lowerLeft" "R0" "stick" 0.0625 nil)
schCreateWire(cv "route" "full" '((0.875 4.688) (1.625 4.688)) 0 0 0 nil nil)
schCreateWireLabel(cv nil '(1.125 4.688) "GIOL" "lowerLeft" "R0" "stick" 0.0625 nil)
schCreateWire(cv "route" "full" '((0.875 5.438) (1.625 5.438)) 0 0 0 nil nil)
schCreateWireLabel(cv nil '(1.125 5.438) "RVDDH" "lowerLeft" "R0" "stick" 0.0625 nil)
dbCreateInst(cv pvss1ac_h_gMaster "CKVSS_left11" '(0 2.8125) "R270")
schCreateWire(cv "route" "full" '((0.000 3.001) (-0.750 3.001)) 0 0 0 nil nil)
schCreateWireLabel(cv nil '(-0.250 3.001) "CKVSS" "lowerRight" "R0" "stick" 0.0625 nil)
schCreatePin(cv nil "CKVSS" "inputOutput" nil '(-0.750 3.001) "R0")
schCreateWire(cv "route" "full" '((0.875 3.062) (1.625 3.062)) 0 0 0 nil nil)
schCreateWireLabel(cv nil '(1.125 3.062) "RVSS" "lowerLeft" "R0" "stick" 0.0625 nil)
schCreateWire(cv "route" "full" '((0.875 2.688) (1.625 2.688)) 0 0 0 nil nil)
schCreateWireLabel(cv nil '(1.125 2.688) "GIOL" "lowerLeft" "R0" "stick" 0.0625 nil)
schCreateWire(cv "route" "full" '((0.875 3.438) (1.625 3.438)) 0 0 0 nil nil)
schCreateWireLabel(cv nil '(1.125 3.438) "RVDDH" "lowerLeft" "R0" "stick" 0.0625 nil)
pvdd1ac_v_gMaster = dbOpenCellView("tphn28hpcpgv18" "PVDD1AC_V_G" "symbol")
dbCreateInst(cv pvdd1ac_v_gMaster "CBVDD_bottom0" '(3.1875 0) "R0")
schCreateWire(cv "route" "full" '((2.938 0.875) (2.938 1.625)) 0 0 0 nil nil)
schCreateWireLabel(cv nil '(2.938 1.125) "RVSS" "lowerLeft" "R90" "stick" 0.0625 nil)
schCreateWire(cv "route" "full" '((3.312 0.875) (3.312 1.625)) 0 0 0 nil nil)
schCreateWireLabel(cv nil '(3.312 1.125) "GIOL" "lowerLeft" "R90" "stick" 0.0625 nil)
schCreateWire(cv "route" "full" '((2.999 0.000) (2.999 -0.750)) 0 0 0 nil nil)
schCreateWireLabel(cv nil '(2.999 -0.250) "CBVDD" "lowerRight" "R90" "stick" 0.0625 nil)
schCreatePin(cv nil "CBVDD" "inputOutput" nil '(2.999 -0.750) "R90")
schCreateWire(cv "route" "full" '((2.562 0.875) (2.562 1.625)) 0 0 0 nil nil)
schCreateWireLabel(cv nil '(2.562 1.125) "RVDDH" "lowerLeft" "R90" "stick" 0.0625 nil)
pdb3ac_v_gMaster = dbOpenCellView("tphn28hpcpgv18" "PDB3AC_V_G" "symbol")
dbCreateInst(cv pdb3ac_v_gMaster "IBIAS_INPL_bottom1" '(5.1875 0) "R0")
schCreateWire(cv "route" "full" '((5.000 0.000) (5.000 -0.750)) 0 0 0 nil nil)
schCreateWireLabel(cv nil '(5.000 -0.250) "IBIAS_INPL" "lowerRight" "R90" "stick" 0.0625 nil)
schCreatePin(cv nil "IBIAS_INPL" "inputOutput" nil '(5.000 -0.750) "R90")
schCreateWire(cv "route" "full" '((4.938 0.875) (4.938 1.625)) 0 0 0 nil nil)
schCreateWireLabel(cv nil '(4.938 1.125) "RVSS" "lowerLeft" "R90" "stick" 0.0625 nil)
schCreateWire(cv "route" "full" '((5.312 0.875) (5.312 1.625)) 0 0 0 nil nil)
schCreateWireLabel(cv nil '(5.312 1.125) "GIOL" "lowerLeft" "R90" "stick" 0.0625 nil)
schCreateWire(cv "route" "full" '((4.562 0.875) (4.562 1.625)) 0 0 0 nil nil)
schCreateWireLabel(cv nil '(4.562 1.125) "RVDDH" "lowerLeft" "R90" "stick" 0.0625 nil)
dbCreateInst(cv pdb3ac_v_gMaster "VCM_bottom2" '(7.1875 0) "R0")
schCreateWire(cv "route" "full" '((7.000 0.000) (7.000 -0.750)) 0 0 0 nil nil)
schCreateWireLabel(cv nil '(7.000 -0.250) "VCM" "lowerRight" "R90" "stick" 0.0625 nil)
schCreatePin(cv nil "VCM" "inputOutput" nil '(7.000 -0.750) "R90")
schCreateWire(cv "route" "full" '((6.938 0.875) (6.938 1.625)) 0 0 0 nil nil)
schCreateWireLabel(cv nil '(6.938 1.125) "RVSS" "lowerLeft" "R90" "stick" 0.0625 nil)
schCreateWire(cv "route" "full" '((7.312 0.875) (7.312 1.625)) 0 0 0 nil nil)
schCreateWireLabel(cv nil '(7.312 1.125) "GIOL" "lowerLeft" "R90" "stick" 0.0625 nil)
schCreateWire(cv "route" "full" '((6.562 0.875) (6.562 1.625)) 0 0 0 nil nil)
schCreateWireLabel(cv nil '(6.562 1.125) "RVDDH" "lowerLeft" "R90" "stick" 0.0625 nil)
pvss1ac_v_gMaster = dbOpenCellView("tphn28hpcpgv18" "PVSS1AC_V_G" "symbol")
dbCreateInst(cv pvss1ac_v_gMaster "AVSSBUF_bottom3" '(9.1875 0) "R0")
schCreateWire(cv "route" "full" '((8.999 0.000) (8.999 -0.750)) 0 0 0 nil nil)
schCreateWireLabel(cv nil '(8.999 -0.250) "AVSSBUF" "lowerRight" "R90" "stick" 0.0625 nil)
schCreatePin(cv nil "AVSSBUF" "inputOutput" nil '(8.999 -0.750) "R90")
schCreateWire(cv "route" "full" '((8.938 0.875) (8.938 1.625)) 0 0 0 nil nil)
schCreateWireLabel(cv nil '(8.938 1.125) "RVSS" "lowerLeft" "R90" "stick" 0.0625 nil)
schCreateWire(cv "route" "full" '((9.312 0.875) (9.312 1.625)) 0 0 0 nil nil)
schCreateWireLabel(cv nil '(9.312 1.125) "GIOL" "lowerLeft" "R90" "stick" 0.0625 nil)
schCreateWire(cv "route" "full" '((8.562 0.875) (8.562 1.625)) 0 0 0 nil nil)
schCreateWireLabel(cv nil '(8.562 1.125) "RVDDH" "lowerLeft" "R90" "stick" 0.0625 nil)
dbCreateInst(cv pdb3ac_v_gMaster "VINP_bottom4" '(11.1875 0) "R0")
schCreateWire(cv "route" "full" '((10.999 0.000) (10.999 -0.750)) 0 0 0 nil nil)
schCreateWireLabel(cv nil '(10.999 -0.250) "VINP" "lowerRight" "R90" "stick" 0.0625 nil)
schCreatePin(cv nil "VINP" "inputOutput" nil '(10.999 -0.750) "R90")
schCreateWire(cv "route" "full" '((10.938 0.875) (10.938 1.625)) 0 0 0 nil nil)
schCreateWireLabel(cv nil '(10.938 1.125) "RVSS" "lowerLeft" "R90" "stick" 0.0625 nil)
schCreateWire(cv "route" "full" '((11.312 0.875) (11.312 1.625)) 0 0 0 nil nil)
schCreateWireLabel(cv nil '(11.312 1.125) "GIOL" "lowerLeft" "R90" "stick" 0.0625 nil)
schCreateWire(cv "route" "full" '((10.562 0.875) (10.562 1.625)) 0 0 0 nil nil)
schCreateWireLabel(cv nil '(10.562 1.125) "RVDDH" "lowerLeft" "R90" "stick" 0.0625 nil)
dbCreateInst(cv pdb3ac_v_gMaster "VINN_bottom5" '(13.1875 0) "R0")
schCreateWire(cv "route" "full" '((12.999 0.000) (12.999 -0.750)) 0 0 0 nil nil)
schCreateWireLabel(cv nil '(12.999 -0.250) "VINN" "lowerRight" "R90" "stick" 0.0625 nil)
schCreatePin(cv nil "VINN" "inputOutput" nil '(12.999 -0.750) "R90")
schCreateWire(cv "route" "full" '((12.938 0.875) (12.938 1.625)) 0 0 0 nil nil)
schCreateWireLabel(cv nil '(12.938 1.125) "RVSS" "lowerLeft" "R90" "stick" 0.0625 nil)
schCreateWire(cv "route" "full" '((13.312 0.875) (13.312 1.625)) 0 0 0 nil nil)
schCreateWireLabel(cv nil '(13.312 1.125) "GIOL" "lowerLeft" "R90" "stick" 0.0625 nil)
schCreateWire(cv "route" "full" '((12.562 0.875) (12.562 1.625)) 0 0 0 nil nil)
schCreateWireLabel(cv nil '(12.562 1.125) "RVDDH" "lowerLeft" "R90" "stick" 0.0625 nil)
dbCreateInst(cv pvss1ac_v_gMaster "AVSS_bottom6" '(15.1875 0) "R0")
schCreateWire(cv "route" "full" '((14.999 0.000) (14.999 -0.750)) 0 0 0 nil nil)
schCreateWireLabel(cv nil '(14.999 -0.250) "AVSS" "lowerRight" "R90" "stick" 0.0625 nil)
schCreatePin(cv nil "AVSS" "inputOutput" nil '(14.999 -0.750) "R90")
schCreateWire(cv "route" "full" '((14.938 0.875) (14.938 1.625)) 0 0 0 nil nil)
schCreateWireLabel(cv nil '(14.938 1.125) "RVSS" "lowerLeft" "R90" "stick" 0.0625 nil)
schCreateWire(cv "route" "full" '((15.312 0.875) (15.312 1.625)) 0 0 0 nil nil)
schCreateWireLabel(cv nil '(15.312 1.125) "GIOL" "lowerLeft" "R90" "stick" 0.0625 nil)
schCreateWire(cv "route" "full" '((14.562 0.875) (14.562 1.625)) 0 0 0 nil nil)
schCreateWireLabel(cv nil '(14.562 1.125) "RVDDH" "lowerLeft" "R90" "stick" 0.0625 nil)
dbCreateInst(cv pvdd1ac_v_gMaster "AVDDBUF_bottom7" '(17.1875 0) "R0")
schCreateWire(cv "route" "full" '((16.938 0.875) (16.938 1.625)) 0 0 0 nil nil)
schCreateWireLabel(cv nil '(16.938 1.125) "RVSS" "lowerLeft" "R90" "stick" 0.0625 nil)
schCreateWire(cv "route" "full" '((17.312 0.875) (17.312 1.625)) 0 0 0 nil nil)
schCreateWireLabel(cv nil '(17.312 1.125) "GIOL" "lowerLeft" "R90" "stick" 0.0625 nil)
schCreateWire(cv "route" "full" '((17.000 0.000) (17.000 -0.750)) 0 0 0 nil nil)
schCreateWireLabel(cv nil '(17.000 -0.250) "AVDDBUF" "lowerRight" "R90" "stick" 0.0625 nil)
schCreatePin(cv nil "AVDDBUF" "inputOutput" nil '(17.000 -0.750) "R90")
schCreateWire(cv "route" "full" '((16.562 0.875) (16.562 1.625)) 0 0 0 nil nil)
schCreateWireLabel(cv nil '(16.562 1.125) "RVDDH" "lowerLeft" "R90" "stick" 0.0625 nil)
dbCreateInst(cv pvdd1ac_v_gMaster "AVDD_bottom8" '(19.1875 0) "R0")
schCreateWire(cv "route" "full" '((18.938 0.875) (18.938 1.625)) 0 0 0 nil nil)
schCreateWireLabel(cv nil '(18.938 1.125) "RVSS" "lowerLeft" "R90" "stick" 0.0625 nil)
schCreateWire(cv "route" "full" '((19.312 0.875) (19.312 1.625)) 0 0 0 nil nil)
schCreateWireLabel(cv nil '(19.312 1.125) "GIOL" "lowerLeft" "R90" "stick" 0.0625 nil)
schCreateWire(cv "route" "full" '((19.000 0.000) (19.000 -0.750)) 0 0 0 nil nil)
schCreateWireLabel(cv nil '(19.000 -0.250) "AVDD" "lowerRight" "R90" "stick" 0.0625 nil)
schCreatePin(cv nil "AVDD" "inputOutput" nil '(19.000 -0.750) "R90")
schCreateWire(cv "route" "full" '((18.562 0.875) (18.562 1.625)) 0 0 0 nil nil)
schCreateWireLabel(cv nil '(18.562 1.125) "RVDDH" "lowerLeft" "R90" "stick" 0.0625 nil)
dbCreateInst(cv pvss1ac_v_gMaster "VCALP_1_bottom9" '(21.1875 0) "R0")
schCreateWire(cv "route" "full" '((21.000 0.000) (21.000 -0.750)) 0 0 0 nil nil)
schCreateWireLabel(cv nil '(21.000 -0.250) "VCALP<1>" "lowerRight" "R90" "stick" 0.0625 nil)
schCreatePin(cv nil "VCALP<1>" "inputOutput" nil '(21.000 -0.750) "R90")
schCreateWire(cv "route" "full" '((20.938 0.875) (20.938 1.625)) 0 0 0 nil nil)
schCreateWireLabel(cv nil '(20.938 1.125) "RVSS" "lowerLeft" "R90" "stick" 0.0625 nil)
schCreateWire(cv "route" "full" '((21.312 0.875) (21.312 1.625)) 0 0 0 nil nil)
schCreateWireLabel(cv nil '(21.312 1.125) "GIOL" "lowerLeft" "R90" "stick" 0.0625 nil)
schCreateWire(cv "route" "full" '((20.562 0.875) (20.562 1.625)) 0 0 0 nil nil)
schCreateWireLabel(cv nil '(20.562 1.125) "RVDDH" "lowerLeft" "R90" "stick" 0.0625 nil)
dbCreateInst(cv pvss1ac_v_gMaster "VCALP_2_bottom10" '(23.1875 0) "R0")
schCreateWire(cv "route" "full" '((23.000 0.000) (23.000 -0.750)) 0 0 0 nil nil)
schCreateWireLabel(cv nil '(23.000 -0.250) "VCALP<2>" "lowerRight" "R90" "stick" 0.0625 nil)
schCreatePin(cv nil "VCALP<2>" "inputOutput" nil '(23.000 -0.750) "R90")
schCreateWire(cv "route" "full" '((22.938 0.875) (22.938 1.625)) 0 0 0 nil nil)
schCreateWireLabel(cv nil '(22.938 1.125) "RVSS" "lowerLeft" "R90" "stick" 0.0625 nil)
schCreateWire(cv "route" "full" '((23.312 0.875) (23.312 1.625)) 0 0 0 nil nil)
schCreateWireLabel(cv nil '(23.312 1.125) "GIOL" "lowerLeft" "R90" "stick" 0.0625 nil)
schCreateWire(cv "route" "full" '((22.562 0.875) (22.562 1.625)) 0 0 0 nil nil)
schCreateWireLabel(cv nil '(22.562 1.125) "RVDDH" "lowerLeft" "R90" "stick" 0.0625 nil)
dbCreateInst(cv pvss1ac_v_gMaster "VSS_bottom11" '(25.1875 0) "R0")
schCreateWire(cv "route" "full" '((25.000 0.000) (25.000 -0.750)) 0 0 0 nil nil)
schCreateWireLabel(cv nil '(25.000 -0.250) "VSS" "lowerRight" "R90" "stick" 0.0625 nil)
schCreatePin(cv nil "VSS" "inputOutput" nil '(25.000 -0.750) "R90")
schCreateWire(cv "route" "full" '((24.938 0.875) (24.938 1.625)) 0 0 0 nil nil)
schCreateWireLabel(cv nil '(24.938 1.125) "RVSS" "lowerLeft" "R90" "stick" 0.0625 nil)
schCreateWire(cv "route" "full" '((25.312 0.875) (25.312 1.625)) 0 0 0 nil nil)
schCreateWireLabel(cv nil '(25.312 1.125) "GIOL" "lowerLeft" "R90" "stick" 0.0625 nil)
schCreateWire(cv "route" "full" '((24.562 0.875) (24.562 1.625)) 0 0 0 nil nil)
schCreateWireLabel(cv nil '(24.562 1.125) "RVDDH" "lowerLeft" "R90" "stick" 0.0625 nil)
dbCreateInst(cv pvss1ac_h_gMaster "VCALN_3_right0" '(28.0 3.1875) "R90")
schCreateWire(cv "route" "full" '((28.000 2.999) (28.750 2.999)) 0 0 0 nil nil)
schCreateWireLabel(cv nil '(28.250 2.999) "VCALN<3>" "lowerLeft" "R0" "stick" 0.0625 nil)
schCreatePin(cv nil "VCALN<3>" "inputOutput" nil '(28.750 2.999) "R180")
schCreateWire(cv "route" "full" '((27.125 2.938) (26.375 2.938)) 0 0 0 nil nil)
schCreateWireLabel(cv nil '(26.875 2.938) "RVSS" "lowerRight" "R0" "stick" 0.0625 nil)
schCreateWire(cv "route" "full" '((27.125 3.312) (26.375 3.312)) 0 0 0 nil nil)
schCreateWireLabel(cv nil '(26.875 3.312) "GIOL" "lowerRight" "R0" "stick" 0.0625 nil)
schCreateWire(cv "route" "full" '((27.125 2.562) (26.375 2.562)) 0 0 0 nil nil)
schCreateWireLabel(cv nil '(26.875 2.562) "RVDDH" "lowerRight" "R0" "stick" 0.0625 nil)
dbCreateInst(cv pvss1ac_h_gMaster "VCALN_2_right1" '(28.0 5.1875) "R90")
schCreateWire(cv "route" "full" '((28.000 5.000) (28.750 5.000)) 0 0 0 nil nil)
schCreateWireLabel(cv nil '(28.250 5.000) "VCALN<2>" "lowerLeft" "R0" "stick" 0.0625 nil)
schCreatePin(cv nil "VCALN<2>" "inputOutput" nil '(28.750 5.000) "R180")
schCreateWire(cv "route" "full" '((27.125 4.938) (26.375 4.938)) 0 0 0 nil nil)
schCreateWireLabel(cv nil '(26.875 4.938) "RVSS" "lowerRight" "R0" "stick" 0.0625 nil)
schCreateWire(cv "route" "full" '((27.125 5.312) (26.375 5.312)) 0 0 0 nil nil)
schCreateWireLabel(cv nil '(26.875 5.312) "GIOL" "lowerRight" "R0" "stick" 0.0625 nil)
schCreateWire(cv "route" "full" '((27.125 4.562) (26.375 4.562)) 0 0 0 nil nil)
schCreateWireLabel(cv nil '(26.875 4.562) "RVDDH" "lowerRight" "R0" "stick" 0.0625 nil)
dbCreateInst(cv pvss1ac_h_gMaster "VCALN_1_right2" '(28.0 7.1875) "R90")
schCreateWire(cv "route" "full" '((28.000 7.000) (28.750 7.000)) 0 0 0 nil nil)
schCreateWireLabel(cv nil '(28.250 7.000) "VCALN<1>" "lowerLeft" "R0" "stick" 0.0625 nil)
schCreatePin(cv nil "VCALN<1>" "inputOutput" nil '(28.750 7.000) "R180")
schCreateWire(cv "route" "full" '((27.125 6.938) (26.375 6.938)) 0 0 0 nil nil)
schCreateWireLabel(cv nil '(26.875 6.938) "RVSS" "lowerRight" "R0" "stick" 0.0625 nil)
schCreateWire(cv "route" "full" '((27.125 7.312) (26.375 7.312)) 0 0 0 nil nil)
schCreateWireLabel(cv nil '(26.875 7.312) "GIOL" "lowerRight" "R0" "stick" 0.0625 nil)
schCreateWire(cv "route" "full" '((27.125 6.562) (26.375 6.562)) 0 0 0 nil nil)
schCreateWireLabel(cv nil '(26.875 6.562) "RVDDH" "lowerRight" "R0" "stick" 0.0625 nil)
dbCreateInst(cv pvss1ac_h_gMaster "VCALN_0_right3" '(28.0 9.1875) "R90")
schCreateWire(cv "route" "full" '((28.000 8.999) (28.750 8.999)) 0 0 0 nil nil)
schCreateWireLabel(cv nil '(28.250 8.999) "VCALN<0>" "lowerLeft" "R0" "stick" 0.0625 nil)
schCreatePin(cv nil "VCALN<0>" "inputOutput" nil '(28.750 8.999) "R180")
schCreateWire(cv "route" "full" '((27.125 8.938) (26.375 8.938)) 0 0 0 nil nil)
schCreateWireLabel(cv nil '(26.875 8.938) "RVSS" "lowerRight" "R0" "stick" 0.0625 nil)
schCreateWire(cv "route" "full" '((27.125 9.312) (26.375 9.312)) 0 0 0 nil nil)
schCreateWireLabel(cv nil '(26.875 9.312) "GIOL" "lowerRight" "R0" "stick" 0.0625 nil)
schCreateWire(cv "route" "full" '((27.125 8.562) (26.375 8.562)) 0 0 0 nil nil)
schCreateWireLabel(cv nil '(26.875 8.562) "RVDDH" "lowerRight" "R0" "stick" 0.0625 nil)
dbCreateInst(cv pvdd1ac_h_gMaster "DVDD_right4" '(28.0 11.1875) "R90")
schCreateWire(cv "route" "full" '((27.125 10.938) (26.375 10.938)) 0 0 0 nil nil)
schCreateWireLabel(cv nil '(26.875 10.938) "RVSS" "lowerRight" "R0" "stick" 0.0625 nil)
schCreateWire(cv "route" "full" '((27.125 11.312) (26.375 11.312)) 0 0 0 nil nil)
schCreateWireLabel(cv nil '(26.875 11.312) "GIOL" "lowerRight" "R0" "stick" 0.0625 nil)
schCreateWire(cv "route" "full" '((28.000 10.999) (28.750 10.999)) 0 0 0 nil nil)
schCreateWireLabel(cv nil '(28.250 10.999) "DVDD" "lowerLeft" "R0" "stick" 0.0625 nil)
schCreatePin(cv nil "DVDD" "inputOutput" nil '(28.750 10.999) "R180")
schCreateWire(cv "route" "full" '((27.125 10.562) (26.375 10.562)) 0 0 0 nil nil)
schCreateWireLabel(cv nil '(26.875 10.562) "RVDDH" "lowerRight" "R0" "stick" 0.0625 nil)
dbCreateInst(cv pvss1ac_h_gMaster "DVSS_right5" '(28.0 13.1875) "R90")
schCreateWire(cv "route" "full" '((28.000 12.999) (28.750 12.999)) 0 0 0 nil nil)
schCreateWireLabel(cv nil '(28.250 12.999) "DVSS" "lowerLeft" "R0" "stick" 0.0625 nil)
schCreatePin(cv nil "DVSS" "inputOutput" nil '(28.750 12.999) "R180")
schCreateWire(cv "route" "full" '((27.125 12.938) (26.375 12.938)) 0 0 0 nil nil)
schCreateWireLabel(cv nil '(26.875 12.938) "RVSS" "lowerRight" "R0" "stick" 0.0625 nil)
schCreateWire(cv "route" "full" '((27.125 13.312) (26.375 13.312)) 0 0 0 nil nil)
schCreateWireLabel(cv nil '(26.875 13.312) "GIOL" "lowerRight" "R0" "stick" 0.0625 nil)
schCreateWire(cv "route" "full" '((27.125 12.562) (26.375 12.562)) 0 0 0 nil nil)
schCreateWireLabel(cv nil '(26.875 12.562) "RVDDH" "lowerRight" "R0" "stick" 0.0625 nil)
dbCreateInst(cv pvss1ac_h_gMaster "CALVSS_right6" '(28.0 15.1875) "R90")
schCreateWire(cv "route" "full" '((28.000 14.999) (28.750 14.999)) 0 0 0 nil nil)
schCreateWireLabel(cv nil '(28.250 14.999) "CALVSS" "lowerLeft" "R0" "stick" 0.0625 nil)
schCreatePin(cv nil "CALVSS" "inputOutput" nil '(28.750 14.999) "R180")
schCreateWire(cv "route" "full" '((27.125 14.938) (26.375 14.938)) 0 0 0 nil nil)
schCreateWireLabel(cv nil '(26.875 14.938) "RVSS" "lowerRight" "R0" "stick" 0.0625 nil)
schCreateWire(cv "route" "full" '((27.125 15.312) (26.375 15.312)) 0 0 0 nil nil)
schCreateWireLabel(cv nil '(26.875 15.312) "GIOL" "lowerRight" "R0" "stick" 0.0625 nil)
schCreateWire(cv "route" "full" '((27.125 14.562) (26.375 14.562)) 0 0 0 nil nil)
schCreateWireLabel(cv nil '(26.875 14.562) "RVDDH" "lowerRight" "R0" "stick" 0.0625 nil)
dbCreateInst(cv pvdd1ac_h_gMaster "CALVDD_right7" '(28.0 17.1875) "R90")
schCreateWire(cv "route" "full" '((27.125 16.938) (26.375 16.938)) 0 0 0 nil nil)
schCreateWireLabel(cv nil '(26.875 16.938) "RVSS" "lowerRight" "R0" "stick" 0.0625 nil)
schCreateWire(cv "route" "full" '((27.125 17.312) (26.375 17.312)) 0 0 0 nil nil)
schCreateWireLabel(cv nil '(26.875 17.312) "GIOL" "lowerRight" "R0" "stick" 0.0625 nil)
schCreateWire(cv "route" "full" '((28.000 17.000) (28.750 17.000)) 0 0 0 nil nil)
schCreateWireLabel(cv nil '(28.250 17.000) "CALVDD" "lowerLeft" "R0" "stick" 0.0625 nil)
schCreatePin(cv nil "CALVDD" "inputOutput" nil '(28.750 17.000) "R180")
schCreateWire(cv "route" "full" '((27.125 16.562) (26.375 16.562)) 0 0 0 nil nil)
schCreateWireLabel(cv nil '(26.875 16.562) "RVDDH" "lowerRight" "R0" "stick" 0.0625 nil)
pvss2dgz_h_gMaster = dbOpenCellView("tphn28hpcpgv18" "PVSS2DGZ_H_G" "symbol")
dbCreateInst(cv pvss2dgz_h_gMaster "VSS_right8" '(28.0 18.0) "R90")
schCreateWire(cv "route" "full" '((27.000 18.375) (26.250 18.375)) 0 0 0 nil nil)
schCreateWireLabel(cv nil '(26.750 18.375) "POC" "lowerRight" "R0" "stick" 0.0625 nil)
schCreateWire(cv "route" "full" '((27.000 18.562) (26.250 18.562)) 0 0 0 nil nil)
schCreateWireLabel(cv nil '(26.750 18.562) "IOVDDL" "lowerRight" "R0" "stick" 0.0625 nil)
schCreateWire(cv "route" "full" '((27.000 18.750) (26.250 18.750)) 0 0 0 nil nil)
schCreateWireLabel(cv nil '(26.750 18.750) "IOVSS" "lowerRight" "R0" "stick" 0.0625 nil)
schCreateWire(cv "route" "full" '((27.000 18.938) (26.250 18.938)) 0 0 0 nil nil)
schCreateWireLabel(cv nil '(26.750 18.938) "IOVDDH" "lowerRight" "R0" "stick" 0.0625 nil)
schCreateWire(cv "route" "full" '((28.000 19.000) (28.750 19.000)) 0 0 0 nil nil)
schCreateWireLabel(cv nil '(28.250 19.000) "VSS" "lowerLeft" "R0" "stick" 0.0625 nil)
schCreatePin(cv nil "VSS" "inputOutput" nil '(28.750 19.000) "R180")
pvss1dgz_h_gMaster = dbOpenCellView("tphn28hpcpgv18" "PVSS1DGZ_H_G" "symbol")
dbCreateInst(cv pvss1dgz_h_gMaster "IOVSS_right9" '(28.0 20.0) "R90")
schCreateWire(cv "route" "full" '((27.000 20.375) (26.250 20.375)) 0 0 0 nil nil)
schCreateWireLabel(cv nil '(26.750 20.375) "POC" "lowerRight" "R0" "stick" 0.0625 nil)
schCreateWire(cv "route" "full" '((27.000 20.562) (26.250 20.562)) 0 0 0 nil nil)
schCreateWireLabel(cv nil '(26.750 20.562) "IOVDDL" "lowerRight" "R0" "stick" 0.0625 nil)
schCreateWire(cv "route" "full" '((28.000 21.000) (28.750 21.000)) 0 0 0 nil nil)
schCreateWireLabel(cv nil '(28.250 21.000) "IOVSS" "lowerLeft" "R0" "stick" 0.0625 nil)
schCreatePin(cv nil "IOVSS" "inputOutput" nil '(28.750 21.000) "R180")
schCreateWire(cv "route" "full" '((27.000 20.938) (26.250 20.938)) 0 0 0 nil nil)
schCreateWireLabel(cv nil '(26.750 20.938) "IOVDDH" "lowerRight" "R0" "stick" 0.0625 nil)
schCreateWire(cv "route" "full" '((27.000 21.312) (26.250 21.312)) 0 0 0 nil nil)
schCreateWireLabel(cv nil '(26.750 21.312) "VSS" "lowerRight" "R0" "stick" 0.0625 nil)
pvdd1dgz_h_gMaster = dbOpenCellView("tphn28hpcpgv18" "PVDD1DGZ_H_G" "symbol")
dbCreateInst(cv pvdd1dgz_h_gMaster "IOVDDL_right10" '(28.0 22.0) "R90")
schCreateWire(cv "route" "full" '((27.000 22.375) (26.250 22.375)) 0 0 0 nil nil)
schCreateWireLabel(cv nil '(26.750 22.375) "POC" "lowerRight" "R0" "stick" 0.0625 nil)
schCreateWire(cv "route" "full" '((28.000 23.000) (28.750 23.000)) 0 0 0 nil nil)
schCreateWireLabel(cv nil '(28.250 23.000) "IOVDDL" "lowerLeft" "R0" "stick" 0.0625 nil)
schCreatePin(cv nil "IOVDDL" "inputOutput" nil '(28.750 23.000) "R180")
schCreateWire(cv "route" "full" '((27.000 22.750) (26.250 22.750)) 0 0 0 nil nil)
schCreateWireLabel(cv nil '(26.750 22.750) "IOVSS" "lowerRight" "R0" "stick" 0.0625 nil)
schCreateWire(cv "route" "full" '((27.000 22.938) (26.250 22.938)) 0 0 0 nil nil)
schCreateWireLabel(cv nil '(26.750 22.938) "IOVDDH" "lowerRight" "R0" "stick" 0.0625 nil)
schCreateWire(cv "route" "full" '((27.000 23.312) (26.250 23.312)) 0 0 0 nil nil)
schCreateWireLabel(cv nil '(26.750 23.312) "VSS" "lowerRight" "R0" "stick" 0.0625 nil)
pvdd2poc_h_gMaster = dbOpenCellView("tphn28hpcpgv18" "PVDD2POC_H_G" "symbol")
dbCreateInst(cv pvdd2poc_h_gMaster "IOVDDH_right11" '(28.0 24.0) "R90")
schCreateWire(cv "route" "full" '((27.000 24.375) (26.250 24.375)) 0 0 0 nil nil)
schCreateWireLabel(cv nil '(26.750 24.375) "POC" "lowerRight" "R0" "stick" 0.0625 nil)
schCreateWire(cv "route" "full" '((27.000 24.562) (26.250 24.562)) 0 0 0 nil nil)
schCreateWireLabel(cv nil '(26.750 24.562) "IOVDDL" "lowerRight" "R0" "stick" 0.0625 nil)
schCreateWire(cv "route" "full" '((27.000 24.750) (26.250 24.750)) 0 0 0 nil nil)
schCreateWireLabel(cv nil '(26.750 24.750) "IOVSS" "lowerRight" "R0" "stick" 0.0625 nil)
schCreateWire(cv "route" "full" '((28.000 25.000) (28.750 25.000)) 0 0 0 nil nil)
schCreateWireLabel(cv nil '(28.250 25.000) "IOVDDH" "lowerLeft" "R0" "stick" 0.0625 nil)
schCreatePin(cv nil "IOVDDH" "inputOutput" nil '(28.750 25.000) "R180")
schCreateWire(cv "route" "full" '((27.000 25.312) (26.250 25.312)) 0 0 0 nil nil)
schCreateWireLabel(cv nil '(26.750 25.312) "VSS" "lowerRight" "R0" "stick" 0.0625 nil)
pddw16sdgz_v_gMaster = dbOpenCellView("tphn28hpcpgv18" "PDDW16SDGZ_V_G" "symbol")
dbCreateInst(cv pddw16sdgz_v_gMaster "CLKO_top0" '(25.6875 28.0) "R180")
schCreateWire(cv "route" "full" '((25.562 27.000) (25.562 26.250)) 0 0 0 nil nil)
schCreateWireLabel(cv nil '(25.562 26.750) "IOVDDL" "lowerRight" "R90" "stick" 0.0625 nil)
noConnMaster = dbOpenCellView("basic" "noConn" "symbol")
schCreateWire(cv "route" "full" '((25.438 27.000) (25.438 26.250)) 0 0 0 nil nil)
dbCreateInst(cv noConnMaster "noConn_CLKO_top0_C" '(25.438 26.250) "R0")
schCreateWire(cv "route" "full" '((25.812 27.000) (25.812 26.250)) 0 0 0 nil nil)
schCreateWireLabel(cv nil '(25.812 26.750) "IOVSS" "lowerRight" "R90" "stick" 0.0625 nil)
schCreateWire(cv "route" "full" '((25.938 27.000) (25.938 26.250)) 0 0 0 nil nil)
schCreateWireLabel(cv nil '(25.938 26.750) "CLKO_CORE" "lowerRight" "R90" "stick" 0.0625 nil)
schCreatePin(cv nil "CLKO_CORE" "inputOutput" nil '(25.938 26.250) "R90")
schCreateWire(cv "route" "full" '((25.000 28.000) (25.000 28.750)) 0 0 0 nil nil)
schCreateWireLabel(cv nil '(25.000 28.250) "CLKO" "lowerLeft" "R90" "stick" 0.0625 nil)
schCreatePin(cv nil "CLKO" "inputOutput" nil '(25.000 28.750) "R270")
schCreateWire(cv "route" "full" '((25.312 27.000) (25.312 26.250)) 0 0 0 nil nil)
schCreateWireLabel(cv nil '(25.312 26.750) "POC" "lowerRight" "R90" "stick" 0.0625 nil)
schCreateWire(cv "route" "full" '((25.125 27.000) (25.125 26.250)) 0 0 0 nil nil)
schCreateWireLabel(cv nil '(25.125 26.750) "IOVDDL" "lowerRight" "R90" "stick" 0.0625 nil)
schCreateWire(cv "route" "full" '((24.938 27.000) (24.938 26.250)) 0 0 0 nil nil)
schCreateWireLabel(cv nil '(24.938 26.750) "IOVSS" "lowerRight" "R90" "stick" 0.0625 nil)
schCreateWire(cv "route" "full" '((24.750 27.000) (24.750 26.250)) 0 0 0 nil nil)
schCreateWireLabel(cv nil '(24.750 26.750) "IOVDDH" "lowerRight" "R90" "stick" 0.0625 nil)
schCreateWire(cv "route" "full" '((24.375 27.000) (24.375 26.250)) 0 0 0 nil nil)
schCreateWireLabel(cv nil '(24.375 26.750) "VSS" "lowerRight" "R90" "stick" 0.0625 nil)
dbCreateInst(cv pddw16sdgz_v_gMaster "D_0_top1" '(23.6875 28.0) "R180")
schCreateWire(cv "route" "full" '((23.562 27.000) (23.562 26.250)) 0 0 0 nil nil)
schCreateWireLabel(cv nil '(23.562 26.750) "IOVDDL" "lowerRight" "R90" "stick" 0.0625 nil)
schCreateWire(cv "route" "full" '((23.438 27.000) (23.438 26.250)) 0 0 0 nil nil)
dbCreateInst(cv noConnMaster "noConn_D_0_top1_C" '(23.438 26.250) "R0")
schCreateWire(cv "route" "full" '((23.812 27.000) (23.812 26.250)) 0 0 0 nil nil)
schCreateWireLabel(cv nil '(23.812 26.750) "IOVSS" "lowerRight" "R90" "stick" 0.0625 nil)
schCreateWire(cv "route" "full" '((23.938 27.000) (23.938 26.250)) 0 0 0 nil nil)
schCreateWireLabel(cv nil '(23.938 26.750) "D_CORE<0>" "lowerRight" "R90" "stick" 0.0625 nil)
schCreatePin(cv nil "D_CORE<0>" "inputOutput" nil '(23.938 26.250) "R90")
schCreateWire(cv "route" "full" '((23.000 28.000) (23.000 28.750)) 0 0 0 nil nil)
schCreateWireLabel(cv nil '(23.000 28.250) "D<0>" "lowerLeft" "R90" "stick" 0.0625 nil)
schCreatePin(cv nil "D<0>" "inputOutput" nil '(23.000 28.750) "R270")
schCreateWire(cv "route" "full" '((23.312 27.000) (23.312 26.250)) 0 0 0 nil nil)
schCreateWireLabel(cv nil '(23.312 26.750) "POC" "lowerRight" "R90" "stick" 0.0625 nil)
schCreateWire(cv "route" "full" '((23.125 27.000) (23.125 26.250)) 0 0 0 nil nil)
schCreateWireLabel(cv nil '(23.125 26.750) "IOVDDL" "lowerRight" "R90" "stick" 0.0625 nil)
schCreateWire(cv "route" "full" '((22.938 27.000) (22.938 26.250)) 0 0 0 nil nil)
schCreateWireLabel(cv nil '(22.938 26.750) "IOVSS" "lowerRight" "R90" "stick" 0.0625 nil)
schCreateWire(cv "route" "full" '((22.750 27.000) (22.750 26.250)) 0 0 0 nil nil)
schCreateWireLabel(cv nil '(22.750 26.750) "IOVDDH" "lowerRight" "R90" "stick" 0.0625 nil)
schCreateWire(cv "route" "full" '((22.375 27.000) (22.375 26.250)) 0 0 0 nil nil)
schCreateWireLabel(cv nil '(22.375 26.750) "VSS" "lowerRight" "R90" "stick" 0.0625 nil)
dbCreateInst(cv pddw16sdgz_v_gMaster "D_1_top2" '(21.6875 28.0) "R180")
schCreateWire(cv "route" "full" '((21.562 27.000) (21.562 26.250)) 0 0 0 nil nil)
schCreateWireLabel(cv nil '(21.562 26.750) "IOVDDL" "lowerRight" "R90" "stick" 0.0625 nil)
schCreateWire(cv "route" "full" '((21.438 27.000) (21.438 26.250)) 0 0 0 nil nil)
dbCreateInst(cv noConnMaster "noConn_D_1_top2_C" '(21.438 26.250) "R0")
schCreateWire(cv "route" "full" '((21.812 27.000) (21.812 26.250)) 0 0 0 nil nil)
schCreateWireLabel(cv nil '(21.812 26.750) "IOVSS" "lowerRight" "R90" "stick" 0.0625 nil)
schCreateWire(cv "route" "full" '((21.938 27.000) (21.938 26.250)) 0 0 0 nil nil)
schCreateWireLabel(cv nil '(21.938 26.750) "D_CORE<1>" "lowerRight" "R90" "stick" 0.0625 nil)
schCreatePin(cv nil "D_CORE<1>" "inputOutput" nil '(21.938 26.250) "R90")
schCreateWire(cv "route" "full" '((21.000 28.000) (21.000 28.750)) 0 0 0 nil nil)
schCreateWireLabel(cv nil '(21.000 28.250) "D<1>" "lowerLeft" "R90" "stick" 0.0625 nil)
schCreatePin(cv nil "D<1>" "inputOutput" nil '(21.000 28.750) "R270")
schCreateWire(cv "route" "full" '((21.312 27.000) (21.312 26.250)) 0 0 0 nil nil)
schCreateWireLabel(cv nil '(21.312 26.750) "POC" "lowerRight" "R90" "stick" 0.0625 nil)
schCreateWire(cv "route" "full" '((21.125 27.000) (21.125 26.250)) 0 0 0 nil nil)
schCreateWireLabel(cv nil '(21.125 26.750) "IOVDDL" "lowerRight" "R90" "stick" 0.0625 nil)
schCreateWire(cv "route" "full" '((20.938 27.000) (20.938 26.250)) 0 0 0 nil nil)
schCreateWireLabel(cv nil '(20.938 26.750) "IOVSS" "lowerRight" "R90" "stick" 0.0625 nil)
schCreateWire(cv "route" "full" '((20.750 27.000) (20.750 26.250)) 0 0 0 nil nil)
schCreateWireLabel(cv nil '(20.750 26.750) "IOVDDH" "lowerRight" "R90" "stick" 0.0625 nil)
schCreateWire(cv "route" "full" '((20.375 27.000) (20.375 26.250)) 0 0 0 nil nil)
schCreateWireLabel(cv nil '(20.375 26.750) "VSS" "lowerRight" "R90" "stick" 0.0625 nil)
dbCreateInst(cv pddw16sdgz_v_gMaster "D_2_top3" '(19.6875 28.0) "R180")
schCreateWire(cv "route" "full" '((19.562 27.000) (19.562 26.250)) 0 0 0 nil nil)
schCreateWireLabel(cv nil '(19.562 26.750) "IOVDDL" "lowerRight" "R90" "stick" 0.0625 nil)
schCreateWire(cv "route" "full" '((19.438 27.000) (19.438 26.250)) 0 0 0 nil nil)
dbCreateInst(cv noConnMaster "noConn_D_2_top3_C" '(19.438 26.250) "R0")
schCreateWire(cv "route" "full" '((19.812 27.000) (19.812 26.250)) 0 0 0 nil nil)
schCreateWireLabel(cv nil '(19.812 26.750) "IOVSS" "lowerRight" "R90" "stick" 0.0625 nil)
schCreateWire(cv "route" "full" '((19.938 27.000) (19.938 26.250)) 0 0 0 nil nil)
schCreateWireLabel(cv nil '(19.938 26.750) "D_CORE<2>" "lowerRight" "R90" "stick" 0.0625 nil)
schCreatePin(cv nil "D_CORE<2>" "inputOutput" nil '(19.938 26.250) "R90")
schCreateWire(cv "route" "full" '((19.000 28.000) (19.000 28.750)) 0 0 0 nil nil)
schCreateWireLabel(cv nil '(19.000 28.250) "D<2>" "lowerLeft" "R90" "stick" 0.0625 nil)
schCreatePin(cv nil "D<2>" "inputOutput" nil '(19.000 28.750) "R270")
schCreateWire(cv "route" "full" '((19.312 27.000) (19.312 26.250)) 0 0 0 nil nil)
schCreateWireLabel(cv nil '(19.312 26.750) "POC" "lowerRight" "R90" "stick" 0.0625 nil)
schCreateWire(cv "route" "full" '((19.125 27.000) (19.125 26.250)) 0 0 0 nil nil)
schCreateWireLabel(cv nil '(19.125 26.750) "IOVDDL" "lowerRight" "R90" "stick" 0.0625 nil)
schCreateWire(cv "route" "full" '((18.938 27.000) (18.938 26.250)) 0 0 0 nil nil)
schCreateWireLabel(cv nil '(18.938 26.750) "IOVSS" "lowerRight" "R90" "stick" 0.0625 nil)
schCreateWire(cv "route" "full" '((18.750 27.000) (18.750 26.250)) 0 0 0 nil nil)
schCreateWireLabel(cv nil '(18.750 26.750) "IOVDDH" "lowerRight" "R90" "stick" 0.0625 nil)
schCreateWire(cv "route" "full" '((18.375 27.000) (18.375 26.250)) 0 0 0 nil nil)
schCreateWireLabel(cv nil '(18.375 26.750) "VSS" "lowerRight" "R90" "stick" 0.0625 nil)
dbCreateInst(cv pddw16sdgz_v_gMaster "D_3_top4" '(17.6875 28.0) "R180")
schCreateWire(cv "route" "full" '((17.562 27.000) (17.562 26.250)) 0 0 0 nil nil)
schCreateWireLabel(cv nil '(17.562 26.750) "IOVDDL" "lowerRight" "R90" "stick" 0.0625 nil)
schCreateWire(cv "route" "full" '((17.438 27.000) (17.438 26.250)) 0 0 0 nil nil)
dbCreateInst(cv noConnMaster "noConn_D_3_top4_C" '(17.438 26.250) "R0")
schCreateWire(cv "route" "full" '((17.812 27.000) (17.812 26.250)) 0 0 0 nil nil)
schCreateWireLabel(cv nil '(17.812 26.750) "IOVSS" "lowerRight" "R90" "stick" 0.0625 nil)
schCreateWire(cv "route" "full" '((17.938 27.000) (17.938 26.250)) 0 0 0 nil nil)
schCreateWireLabel(cv nil '(17.938 26.750) "D_CORE<3>" "lowerRight" "R90" "stick" 0.0625 nil)
schCreatePin(cv nil "D_CORE<3>" "inputOutput" nil '(17.938 26.250) "R90")
schCreateWire(cv "route" "full" '((17.000 28.000) (17.000 28.750)) 0 0 0 nil nil)
schCreateWireLabel(cv nil '(17.000 28.250) "D<3>" "lowerLeft" "R90" "stick" 0.0625 nil)
schCreatePin(cv nil "D<3>" "inputOutput" nil '(17.000 28.750) "R270")
schCreateWire(cv "route" "full" '((17.312 27.000) (17.312 26.250)) 0 0 0 nil nil)
schCreateWireLabel(cv nil '(17.312 26.750) "POC" "lowerRight" "R90" "stick" 0.0625 nil)
schCreateWire(cv "route" "full" '((17.125 27.000) (17.125 26.250)) 0 0 0 nil nil)
schCreateWireLabel(cv nil '(17.125 26.750) "IOVDDL" "lowerRight" "R90" "stick" 0.0625 nil)
schCreateWire(cv "route" "full" '((16.938 27.000) (16.938 26.250)) 0 0 0 nil nil)
schCreateWireLabel(cv nil '(16.938 26.750) "IOVSS" "lowerRight" "R90" "stick" 0.0625 nil)
schCreateWire(cv "route" "full" '((16.750 27.000) (16.750 26.250)) 0 0 0 nil nil)
schCreateWireLabel(cv nil '(16.750 26.750) "IOVDDH" "lowerRight" "R90" "stick" 0.0625 nil)
schCreateWire(cv "route" "full" '((16.375 27.000) (16.375 26.250)) 0 0 0 nil nil)
schCreateWireLabel(cv nil '(16.375 26.750) "VSS" "lowerRight" "R90" "stick" 0.0625 nil)
dbCreateInst(cv pddw16sdgz_v_gMaster "D_4_top5" '(15.6875 28.0) "R180")
schCreateWire(cv "route" "full" '((15.562 27.000) (15.562 26.250)) 0 0 0 nil nil)
schCreateWireLabel(cv nil '(15.562 26.750) "IOVDDL" "lowerRight" "R90" "stick" 0.0625 nil)
schCreateWire(cv "route" "full" '((15.438 27.000) (15.438 26.250)) 0 0 0 nil nil)
dbCreateInst(cv noConnMaster "noConn_D_4_top5_C" '(15.438 26.250) "R0")
schCreateWire(cv "route" "full" '((15.812 27.000) (15.812 26.250)) 0 0 0 nil nil)
schCreateWireLabel(cv nil '(15.812 26.750) "IOVSS" "lowerRight" "R90" "stick" 0.0625 nil)
schCreateWire(cv "route" "full" '((15.938 27.000) (15.938 26.250)) 0 0 0 nil nil)
schCreateWireLabel(cv nil '(15.938 26.750) "D_CORE<4>" "lowerRight" "R90" "stick" 0.0625 nil)
schCreatePin(cv nil "D_CORE<4>" "inputOutput" nil '(15.938 26.250) "R90")
schCreateWire(cv "route" "full" '((14.999 28.000) (14.999 28.750)) 0 0 0 nil nil)
schCreateWireLabel(cv nil '(14.999 28.250) "D<4>" "lowerLeft" "R90" "stick" 0.0625 nil)
schCreatePin(cv nil "D<4>" "inputOutput" nil '(14.999 28.750) "R270")
schCreateWire(cv "route" "full" '((15.312 27.000) (15.312 26.250)) 0 0 0 nil nil)
schCreateWireLabel(cv nil '(15.312 26.750) "POC" "lowerRight" "R90" "stick" 0.0625 nil)
schCreateWire(cv "route" "full" '((15.126 27.000) (15.126 26.250)) 0 0 0 nil nil)
schCreateWireLabel(cv nil '(15.126 26.750) "IOVDDL" "lowerRight" "R90" "stick" 0.0625 nil)
schCreateWire(cv "route" "full" '((14.938 27.000) (14.938 26.250)) 0 0 0 nil nil)
schCreateWireLabel(cv nil '(14.938 26.750) "IOVSS" "lowerRight" "R90" "stick" 0.0625 nil)
schCreateWire(cv "route" "full" '((14.749 27.000) (14.749 26.250)) 0 0 0 nil nil)
schCreateWireLabel(cv nil '(14.749 26.750) "IOVDDH" "lowerRight" "R90" "stick" 0.0625 nil)
schCreateWire(cv "route" "full" '((14.376 27.000) (14.376 26.250)) 0 0 0 nil nil)
schCreateWireLabel(cv nil '(14.376 26.750) "VSS" "lowerRight" "R90" "stick" 0.0625 nil)
dbCreateInst(cv pddw16sdgz_v_gMaster "D_5_top6" '(13.6875 28.0) "R180")
schCreateWire(cv "route" "full" '((13.562 27.000) (13.562 26.250)) 0 0 0 nil nil)
schCreateWireLabel(cv nil '(13.562 26.750) "IOVDDL" "lowerRight" "R90" "stick" 0.0625 nil)
schCreateWire(cv "route" "full" '((13.438 27.000) (13.438 26.250)) 0 0 0 nil nil)
dbCreateInst(cv noConnMaster "noConn_D_5_top6_C" '(13.438 26.250) "R0")
schCreateWire(cv "route" "full" '((13.812 27.000) (13.812 26.250)) 0 0 0 nil nil)
schCreateWireLabel(cv nil '(13.812 26.750) "IOVSS" "lowerRight" "R90" "stick" 0.0625 nil)
schCreateWire(cv "route" "full" '((13.938 27.000) (13.938 26.250)) 0 0 0 nil nil)
schCreateWireLabel(cv nil '(13.938 26.750) "D_CORE<5>" "lowerRight" "R90" "stick" 0.0625 nil)
schCreatePin(cv nil "D_CORE<5>" "inputOutput" nil '(13.938 26.250) "R90")
schCreateWire(cv "route" "full" '((12.999 28.000) (12.999 28.750)) 0 0 0 nil nil)
schCreateWireLabel(cv nil '(12.999 28.250) "D<5>" "lowerLeft" "R90" "stick" 0.0625 nil)
schCreatePin(cv nil "D<5>" "inputOutput" nil '(12.999 28.750) "R270")
schCreateWire(cv "route" "full" '((13.312 27.000) (13.312 26.250)) 0 0 0 nil nil)
schCreateWireLabel(cv nil '(13.312 26.750) "POC" "lowerRight" "R90" "stick" 0.0625 nil)
schCreateWire(cv "route" "full" '((13.126 27.000) (13.126 26.250)) 0 0 0 nil nil)
schCreateWireLabel(cv nil '(13.126 26.750) "IOVDDL" "lowerRight" "R90" "stick" 0.0625 nil)
schCreateWire(cv "route" "full" '((12.938 27.000) (12.938 26.250)) 0 0 0 nil nil)
schCreateWireLabel(cv nil '(12.938 26.750) "IOVSS" "lowerRight" "R90" "stick" 0.0625 nil)
schCreateWire(cv "route" "full" '((12.749 27.000) (12.749 26.250)) 0 0 0 nil nil)
schCreateWireLabel(cv nil '(12.749 26.750) "IOVDDH" "lowerRight" "R90" "stick" 0.0625 nil)
schCreateWire(cv "route" "full" '((12.376 27.000) (12.376 26.250)) 0 0 0 nil nil)
schCreateWireLabel(cv nil '(12.376 26.750) "VSS" "lowerRight" "R90" "stick" 0.0625 nil)
dbCreateInst(cv pddw16sdgz_v_gMaster "D_6_top7" '(11.6875 28.0) "R180")
schCreateWire(cv "route" "full" '((11.562 27.000) (11.562 26.250)) 0 0 0 nil nil)
schCreateWireLabel(cv nil '(11.562 26.750) "IOVDDL" "lowerRight" "R90" "stick" 0.0625 nil)
schCreateWire(cv "route" "full" '((11.438 27.000) (11.438 26.250)) 0 0 0 nil nil)
dbCreateInst(cv noConnMaster "noConn_D_6_top7_C" '(11.438 26.250) "R0")
schCreateWire(cv "route" "full" '((11.812 27.000) (11.812 26.250)) 0 0 0 nil nil)
schCreateWireLabel(cv nil '(11.812 26.750) "IOVSS" "lowerRight" "R90" "stick" 0.0625 nil)
schCreateWire(cv "route" "full" '((11.938 27.000) (11.938 26.250)) 0 0 0 nil nil)
schCreateWireLabel(cv nil '(11.938 26.750) "D_CORE<6>" "lowerRight" "R90" "stick" 0.0625 nil)
schCreatePin(cv nil "D_CORE<6>" "inputOutput" nil '(11.938 26.250) "R90")
schCreateWire(cv "route" "full" '((10.999 28.000) (10.999 28.750)) 0 0 0 nil nil)
schCreateWireLabel(cv nil '(10.999 28.250) "D<6>" "lowerLeft" "R90" "stick" 0.0625 nil)
schCreatePin(cv nil "D<6>" "inputOutput" nil '(10.999 28.750) "R270")
schCreateWire(cv "route" "full" '((11.312 27.000) (11.312 26.250)) 0 0 0 nil nil)
schCreateWireLabel(cv nil '(11.312 26.750) "POC" "lowerRight" "R90" "stick" 0.0625 nil)
schCreateWire(cv "route" "full" '((11.126 27.000) (11.126 26.250)) 0 0 0 nil nil)
schCreateWireLabel(cv nil '(11.126 26.750) "IOVDDL" "lowerRight" "R90" "stick" 0.0625 nil)
schCreateWire(cv "route" "full" '((10.938 27.000) (10.938 26.250)) 0 0 0 nil nil)
schCreateWireLabel(cv nil '(10.938 26.750) "IOVSS" "lowerRight" "R90" "stick" 0.0625 nil)
schCreateWire(cv "route" "full" '((10.749 27.000) (10.749 26.250)) 0 0 0 nil nil)
schCreateWireLabel(cv nil '(10.749 26.750) "IOVDDH" "lowerRight" "R90" "stick" 0.0625 nil)
schCreateWire(cv "route" "full" '((10.376 27.000) (10.376 26.250)) 0 0 0 nil nil)
schCreateWireLabel(cv nil '(10.376 26.750) "VSS" "lowerRight" "R90" "stick" 0.0625 nil)
dbCreateInst(cv pddw16sdgz_v_gMaster "SDO_top8" '(9.6875 28.0) "R180")
schCreateWire(cv "route" "full" '((9.562 27.000) (9.562 26.250)) 0 0 0 nil nil)
schCreateWireLabel(cv nil '(9.562 26.750) "IOVDDL" "lowerRight" "R90" "stick" 0.0625 nil)
schCreateWire(cv "route" "full" '((9.438 27.000) (9.438 26.250)) 0 0 0 nil nil)
dbCreateInst(cv noConnMaster "noConn_SDO_top8_C" '(9.438 26.250) "R0")
schCreateWire(cv "route" "full" '((9.812 27.000) (9.812 26.250)) 0 0 0 nil nil)
schCreateWireLabel(cv nil '(9.812 26.750) "IOVSS" "lowerRight" "R90" "stick" 0.0625 nil)
schCreateWire(cv "route" "full" '((9.938 27.000) (9.938 26.250)) 0 0 0 nil nil)
schCreateWireLabel(cv nil '(9.938 26.750) "SDO_CORE" "lowerRight" "R90" "stick" 0.0625 nil)
schCreatePin(cv nil "SDO_CORE" "inputOutput" nil '(9.938 26.250) "R90")
schCreateWire(cv "route" "full" '((8.999 28.000) (8.999 28.750)) 0 0 0 nil nil)
schCreateWireLabel(cv nil '(8.999 28.250) "SDO" "lowerLeft" "R90" "stick" 0.0625 nil)
schCreatePin(cv nil "SDO" "inputOutput" nil '(8.999 28.750) "R270")
schCreateWire(cv "route" "full" '((9.312 27.000) (9.312 26.250)) 0 0 0 nil nil)
schCreateWireLabel(cv nil '(9.312 26.750) "POC" "lowerRight" "R90" "stick" 0.0625 nil)
schCreateWire(cv "route" "full" '((9.126 27.000) (9.126 26.250)) 0 0 0 nil nil)
schCreateWireLabel(cv nil '(9.126 26.750) "IOVDDL" "lowerRight" "R90" "stick" 0.0625 nil)
schCreateWire(cv "route" "full" '((8.938 27.000) (8.938 26.250)) 0 0 0 nil nil)
schCreateWireLabel(cv nil '(8.938 26.750) "IOVSS" "lowerRight" "R90" "stick" 0.0625 nil)
schCreateWire(cv "route" "full" '((8.749 27.000) (8.749 26.250)) 0 0 0 nil nil)
schCreateWireLabel(cv nil '(8.749 26.750) "IOVDDH" "lowerRight" "R90" "stick" 0.0625 nil)
schCreateWire(cv "route" "full" '((8.376 27.000) (8.376 26.250)) 0 0 0 nil nil)
schCreateWireLabel(cv nil '(8.376 26.750) "VSS" "lowerRight" "R90" "stick" 0.0625 nil)
dbCreateInst(cv pddw16sdgz_v_gMaster "SDI_top9" '(7.6875 28.0) "R180")
schCreateWire(cv "route" "full" '((7.562 27.000) (7.562 26.250)) 0 0 0 nil nil)
schCreateWireLabel(cv nil '(7.562 26.750) "IOVSS" "lowerRight" "R90" "stick" 0.0625 nil)
schCreateWire(cv "route" "full" '((7.438 27.000) (7.438 26.250)) 0 0 0 nil nil)
schCreateWireLabel(cv nil '(7.438 26.750) "SDI_CORE" "lowerRight" "R90" "stick" 0.0625 nil)
schCreatePin(cv nil "SDI_CORE" "inputOutput" nil '(7.438 26.250) "R90")
schCreateWire(cv "route" "full" '((7.812 27.000) (7.812 26.250)) 0 0 0 nil nil)
schCreateWireLabel(cv nil '(7.812 26.750) "IOVDDL" "lowerRight" "R90" "stick" 0.0625 nil)
schCreateWire(cv "route" "full" '((7.938 27.000) (7.938 26.250)) 0 0 0 nil nil)
schCreateWireLabel(cv nil '(7.938 26.750) "IOVSS" "lowerRight" "R90" "stick" 0.0625 nil)
schCreateWire(cv "route" "full" '((7.000 28.000) (7.000 28.750)) 0 0 0 nil nil)
schCreateWireLabel(cv nil '(7.000 28.250) "SDI" "lowerLeft" "R90" "stick" 0.0625 nil)
schCreatePin(cv nil "SDI" "inputOutput" nil '(7.000 28.750) "R270")
schCreateWire(cv "route" "full" '((7.312 27.000) (7.312 26.250)) 0 0 0 nil nil)
schCreateWireLabel(cv nil '(7.312 26.750) "POC" "lowerRight" "R90" "stick" 0.0625 nil)
schCreateWire(cv "route" "full" '((7.125 27.000) (7.125 26.250)) 0 0 0 nil nil)
schCreateWireLabel(cv nil '(7.125 26.750) "IOVDDL" "lowerRight" "R90" "stick" 0.0625 nil)
schCreateWire(cv "route" "full" '((6.938 27.000) (6.938 26.250)) 0 0 0 nil nil)
schCreateWireLabel(cv nil '(6.938 26.750) "IOVSS" "lowerRight" "R90" "stick" 0.0625 nil)
schCreateWire(cv "route" "full" '((6.750 27.000) (6.750 26.250)) 0 0 0 nil nil)
schCreateWireLabel(cv nil '(6.750 26.750) "IOVDDH" "lowerRight" "R90" "stick" 0.0625 nil)
schCreateWire(cv "route" "full" '((6.375 27.000) (6.375 26.250)) 0 0 0 nil nil)
schCreateWireLabel(cv nil '(6.375 26.750) "VSS" "lowerRight" "R90" "stick" 0.0625 nil)
dbCreateInst(cv pddw16sdgz_v_gMaster "SCK_top10" '(5.6875 28.0) "R180")
schCreateWire(cv "route" "full" '((5.562 27.000) (5.562 26.250)) 0 0 0 nil nil)
schCreateWireLabel(cv nil '(5.562 26.750) "IOVSS" "lowerRight" "R90" "stick" 0.0625 nil)
schCreateWire(cv "route" "full" '((5.438 27.000) (5.438 26.250)) 0 0 0 nil nil)
schCreateWireLabel(cv nil '(5.438 26.750) "SCK_CORE" "lowerRight" "R90" "stick" 0.0625 nil)
schCreatePin(cv nil "SCK_CORE" "inputOutput" nil '(5.438 26.250) "R90")
schCreateWire(cv "route" "full" '((5.812 27.000) (5.812 26.250)) 0 0 0 nil nil)
schCreateWireLabel(cv nil '(5.812 26.750) "IOVDDL" "lowerRight" "R90" "stick" 0.0625 nil)
schCreateWire(cv "route" "full" '((5.938 27.000) (5.938 26.250)) 0 0 0 nil nil)
schCreateWireLabel(cv nil '(5.938 26.750) "IOVSS" "lowerRight" "R90" "stick" 0.0625 nil)
schCreateWire(cv "route" "full" '((5.000 28.000) (5.000 28.750)) 0 0 0 nil nil)
schCreateWireLabel(cv nil '(5.000 28.250) "SCK" "lowerLeft" "R90" "stick" 0.0625 nil)
schCreatePin(cv nil "SCK" "inputOutput" nil '(5.000 28.750) "R270")
schCreateWire(cv "route" "full" '((5.312 27.000) (5.312 26.250)) 0 0 0 nil nil)
schCreateWireLabel(cv nil '(5.312 26.750) "POC" "lowerRight" "R90" "stick" 0.0625 nil)
schCreateWire(cv "route" "full" '((5.125 27.000) (5.125 26.250)) 0 0 0 nil nil)
schCreateWireLabel(cv nil '(5.125 26.750) "IOVDDL" "lowerRight" "R90" "stick" 0.0625 nil)
schCreateWire(cv "route" "full" '((4.938 27.000) (4.938 26.250)) 0 0 0 nil nil)
schCreateWireLabel(cv nil '(4.938 26.750) "IOVSS" "lowerRight" "R90" "stick" 0.0625 nil)
schCreateWire(cv "route" "full" '((4.750 27.000) (4.750 26.250)) 0 0 0 nil nil)
schCreateWireLabel(cv nil '(4.750 26.750) "IOVDDH" "lowerRight" "R90" "stick" 0.0625 nil)
schCreateWire(cv "route" "full" '((4.375 27.000) (4.375 26.250)) 0 0 0 nil nil)
schCreateWireLabel(cv nil '(4.375 26.750) "VSS" "lowerRight" "R90" "stick" 0.0625 nil)
dbCreateInst(cv pddw16sdgz_v_gMaster "RSTN_top11" '(3.6875 28.0) "R180")
schCreateWire(cv "route" "full" '((3.562 27.000) (3.562 26.250)) 0 0 0 nil nil)
schCreateWireLabel(cv nil '(3.562 26.750) "IOVSS" "lowerRight" "R90" "stick" 0.0625 nil)
schCreateWire(cv "route" "full" '((3.438 27.000) (3.438 26.250)) 0 0 0 nil nil)
schCreateWireLabel(cv nil '(3.438 26.750) "RSTN_CORE" "lowerRight" "R90" "stick" 0.0625 nil)
schCreatePin(cv nil "RSTN_CORE" "inputOutput" nil '(3.438 26.250) "R90")
schCreateWire(cv "route" "full" '((3.812 27.000) (3.812 26.250)) 0 0 0 nil nil)
schCreateWireLabel(cv nil '(3.812 26.750) "IOVDDL" "lowerRight" "R90" "stick" 0.0625 nil)
schCreateWire(cv "route" "full" '((3.938 27.000) (3.938 26.250)) 0 0 0 nil nil)
schCreateWireLabel(cv nil '(3.938 26.750) "IOVSS" "lowerRight" "R90" "stick" 0.0625 nil)
schCreateWire(cv "route" "full" '((3.000 28.000) (3.000 28.750)) 0 0 0 nil nil)
schCreateWireLabel(cv nil '(3.000 28.250) "RSTN" "lowerLeft" "R90" "stick" 0.0625 nil)
schCreatePin(cv nil "RSTN" "inputOutput" nil '(3.000 28.750) "R270")
schCreateWire(cv "route" "full" '((3.312 27.000) (3.312 26.250)) 0 0 0 nil nil)
schCreateWireLabel(cv nil '(3.312 26.750) "POC" "lowerRight" "R90" "stick" 0.0625 nil)
schCreateWire(cv "route" "full" '((3.125 27.000) (3.125 26.250)) 0 0 0 nil nil)
schCreateWireLabel(cv nil '(3.125 26.750) "IOVDDL" "lowerRight" "R90" "stick" 0.0625 nil)
schCreateWire(cv "route" "full" '((2.938 27.000) (2.938 26.250)) 0 0 0 nil nil)
schCreateWireLabel(cv nil '(2.938 26.750) "IOVSS" "lowerRight" "R90" "stick" 0.0625 nil)
schCreateWire(cv "route" "full" '((2.750 27.000) (2.750 26.250)) 0 0 0 nil nil)
schCreateWireLabel(cv nil '(2.750 26.750) "IOVDDH" "lowerRight" "R90" "stick" 0.0625 nil)
schCreateWire(cv "route" "full" '((2.375 27.000) (2.375 26.250)) 0 0 0 nil nil)
schCreateWireLabel(cv nil '(2.375 26.750) "VSS" "lowerRight" "R90" "stick" 0.0625 nil)
schCheck(cv)
dbSave(cv)
t
