cv = geGetWindowCellView()
; Generated Layout Script with Dual Ring Support

; ==================== All Components (Sorted by Placement Order) ====================
dbCreateParamInstByMasterName(cv "tphn28hpcpgv18" "PDB3AC_H_G" "layout" "VCM_left_11" list(0 150) "R270")
dbCreateParamInstByMasterName(cv "PAD" "PAD60GU" "layout" "pad60gu_VCM_left_11" list(0 150) "R270")
dbCreateParamInstByMasterName(cv "tphn28hpcpgv18" "PDB3AC_H_G" "layout" "VREFPF0_left_10" list(0 210) "R270")
dbCreateParamInstByMasterName(cv "PAD" "PAD60GU" "layout" "pad60gu_VREFPF0_left_10" list(0 210) "R270")
dbCreateParamInstByMasterName(cv "tphn28hpcpgv18" "PDB3AC_H_G" "layout" "VREFNF1_left_9" list(0 270) "R270")
dbCreateParamInstByMasterName(cv "PAD" "PAD60GU" "layout" "pad60gu_VREFNF1_left_9" list(0 270) "R270")
dbCreateParamInstByMasterName(cv "tphn28hpcpgv18" "PDB3AC_H_G" "layout" "IBOTA1_left_8" list(0 330) "R270")
dbCreateParamInstByMasterName(cv "PAD" "PAD60GU" "layout" "pad60gu_IBOTA1_left_8" list(0 330) "R270")
dbCreateParamInstByMasterName(cv "tphn28hpcpgv18" "PDB3AC_H_G" "layout" "IBOTA3_left_7" list(0 390) "R270")
dbCreateParamInstByMasterName(cv "PAD" "PAD60GU" "layout" "pad60gu_IBOTA3_left_7" list(0 390) "R270")
dbCreateParamInstByMasterName(cv "tphn28hpcpgv18" "PVSS1AC_H_G" "layout" "FVSS_left_6" list(0 450) "R270")
dbCreateParamInstByMasterName(cv "PAD" "PAD60GU" "layout" "pad60gu_FVSS_left_6" list(0 450) "R270")
dbCreateParamInstByMasterName(cv "tphn28hpcpgv18" "PVDD1AC_H_G" "layout" "FVDDH_left_5" list(0 510) "R270")
dbCreateParamInstByMasterName(cv "PAD" "PAD60GU" "layout" "pad60gu_FVDDH_left_5" list(0 510) "R270")
dbCreateParamInstByMasterName(cv "tphn28hpcpgv18" "PVDD1AC_H_G" "layout" "FVDD_left_4" list(0 570) "R270")
dbCreateParamInstByMasterName(cv "PAD" "PAD60GU" "layout" "pad60gu_FVDD_left_4" list(0 570) "R270")
dbCreateParamInstByMasterName(cv "tphn28hpcpgv18" "PVDD3AC_H_G" "layout" "AVDDH2_left_3" list(0 630) "R270")
dbCreateParamInstByMasterName(cv "PAD" "PAD60GU" "layout" "pad60gu_AVDDH2_left_3" list(0 630) "R270")
dbCreateParamInstByMasterName(cv "tphn28hpcpgv18" "PVDD3AC_H_G" "layout" "AVDDH2_left_2" list(0 690) "R270")
dbCreateParamInstByMasterName(cv "PAD" "PAD60GU" "layout" "pad60gu_AVDDH2_left_2" list(0 690) "R270")
dbCreateParamInstByMasterName(cv "tphn28hpcpgv18" "PVSS3AC_H_G" "layout" "AVSS2_left_1" list(0 750) "R270")
dbCreateParamInstByMasterName(cv "PAD" "PAD60GU" "layout" "pad60gu_AVSS2_left_1" list(0 750) "R270")
dbCreateParamInstByMasterName(cv "tphn28hpcpgv18" "PVSS3AC_H_G" "layout" "AVSS2_left_0" list(0 810) "R270")
dbCreateParamInstByMasterName(cv "PAD" "PAD60GU" "layout" "pad60gu_AVSS2_left_0" list(0 810) "R270")
dbCreateParamInstByMasterName(cv "tphn28hpcpgv18" "PCORNERA_G" "layout" "CORNER_TOP_LEFT_top_left" list(0 940) "R270")
dbCreateParamInstByMasterName(cv "tphn28hpcpgv18" "PVDD1AC_V_G" "layout" "AVDDH1_bottom_25" list(1630 0) "R0")
dbCreateParamInstByMasterName(cv "PAD" "PAD60GU" "layout" "pad60gu_AVDDH1_bottom_25" list(1630 0) "R0")
dbCreateParamInstByMasterName(cv "tphn28hpcpgv18" "PVDD1AC_V_G" "layout" "AVDDH1_bottom_24" list(1570 0) "R0")
dbCreateParamInstByMasterName(cv "PAD" "PAD60GU" "layout" "pad60gu_AVDDH1_bottom_24" list(1570 0) "R0")
dbCreateParamInstByMasterName(cv "tphn28hpcpgv18" "PVSS3AC_V_G" "layout" "AVSS1_bottom_23" list(1510 0) "R0")
dbCreateParamInstByMasterName(cv "PAD" "PAD60GU" "layout" "pad60gu_AVSS1_bottom_23" list(1510 0) "R0")
dbCreateParamInstByMasterName(cv "tphn28hpcpgv18" "PVSS3AC_V_G" "layout" "AVSS1_bottom_22" list(1450 0) "R0")
dbCreateParamInstByMasterName(cv "PAD" "PAD60GU" "layout" "pad60gu_AVSS1_bottom_22" list(1450 0) "R0")
dbCreateParamInstByMasterName(cv "tphn28hpcpgv18" "PVDD3AC_V_G" "layout" "VREFP1_bottom_21" list(1390 0) "R0")
dbCreateParamInstByMasterName(cv "PAD" "PAD60GU" "layout" "pad60gu_VREFP1_bottom_21" list(1390 0) "R0")
dbCreateParamInstByMasterName(cv "tphn28hpcpgv18" "PDB3AC_V_G" "layout" "VREFN1_bottom_20" list(1330 0) "R0")
dbCreateParamInstByMasterName(cv "PAD" "PAD60GU" "layout" "pad60gu_VREFN1_bottom_20" list(1330 0) "R0")
dbCreateParamInstByMasterName(cv "tphn28hpcpgv18" "PVDD3AC_V_G" "layout" "AVDDH0_bottom_19" list(1270 0) "R0")
dbCreateParamInstByMasterName(cv "PAD" "PAD60GU" "layout" "pad60gu_AVDDH0_bottom_19" list(1270 0) "R0")
dbCreateParamInstByMasterName(cv "tphn28hpcpgv18" "PVDD3AC_V_G" "layout" "AVDDH0_bottom_18" list(1210 0) "R0")
dbCreateParamInstByMasterName(cv "PAD" "PAD60GU" "layout" "pad60gu_AVDDH0_bottom_18" list(1210 0) "R0")
dbCreateParamInstByMasterName(cv "tphn28hpcpgv18" "PVSS3AC_V_G" "layout" "AVSS0_bottom_17" list(1150 0) "R0")
dbCreateParamInstByMasterName(cv "PAD" "PAD60GU" "layout" "pad60gu_AVSS0_bottom_17" list(1150 0) "R0")
dbCreateParamInstByMasterName(cv "tphn28hpcpgv18" "PVSS3AC_V_G" "layout" "AVSS0_bottom_16" list(1090 0) "R0")
dbCreateParamInstByMasterName(cv "PAD" "PAD60GU" "layout" "pad60gu_AVSS0_bottom_16" list(1090 0) "R0")
dbCreateParamInstByMasterName(cv "tphn28hpcpgv18" "PDB3AC_V_G" "layout" "VREFP0_bottom_15" list(1030 0) "R0")
dbCreateParamInstByMasterName(cv "PAD" "PAD60GU" "layout" "pad60gu_VREFP0_bottom_15" list(1030 0) "R0")
dbCreateParamInstByMasterName(cv "tphn28hpcpgv18" "PDB3AC_V_G" "layout" "VREFN0_bottom_14" list(970 0) "R0")
dbCreateParamInstByMasterName(cv "PAD" "PAD60GU" "layout" "pad60gu_VREFN0_bottom_14" list(970 0) "R0")
dbCreateParamInstByMasterName(cv "tphn28hpcpgv18" "PDB3AC_V_G" "layout" "VINN_bottom_13" list(910 0) "R0")
dbCreateParamInstByMasterName(cv "PAD" "PAD60GU" "layout" "pad60gu_VINN_bottom_13" list(910 0) "R0")
dbCreateParamInstByMasterName(cv "tphn28hpcpgv18" "PDB3AC_V_G" "layout" "VINP_bottom_12" list(850 0) "R0")
dbCreateParamInstByMasterName(cv "PAD" "PAD60GU" "layout" "pad60gu_VINP_bottom_12" list(850 0) "R0")
dbCreateParamInstByMasterName(cv "tphn28hpcpgv18" "PDB3AC_V_G" "layout" "VREFN0_bottom_11" list(790 0) "R0")
dbCreateParamInstByMasterName(cv "PAD" "PAD60GU" "layout" "pad60gu_VREFN0_bottom_11" list(790 0) "R0")
dbCreateParamInstByMasterName(cv "tphn28hpcpgv18" "PDB3AC_V_G" "layout" "VREFP0_bottom_10" list(730 0) "R0")
dbCreateParamInstByMasterName(cv "PAD" "PAD60GU" "layout" "pad60gu_VREFP0_bottom_10" list(730 0) "R0")
dbCreateParamInstByMasterName(cv "tphn28hpcpgv18" "PVSS3AC_V_G" "layout" "AVSS0_bottom_9" list(670 0) "R0")
dbCreateParamInstByMasterName(cv "PAD" "PAD60GU" "layout" "pad60gu_AVSS0_bottom_9" list(670 0) "R0")
dbCreateParamInstByMasterName(cv "tphn28hpcpgv18" "PVSS3AC_V_G" "layout" "AVSS0_bottom_8" list(610 0) "R0")
dbCreateParamInstByMasterName(cv "PAD" "PAD60GU" "layout" "pad60gu_AVSS0_bottom_8" list(610 0) "R0")
dbCreateParamInstByMasterName(cv "tphn28hpcpgv18" "PVDD3AC_V_G" "layout" "AVDDH0_bottom_7" list(550 0) "R0")
dbCreateParamInstByMasterName(cv "PAD" "PAD60GU" "layout" "pad60gu_AVDDH0_bottom_7" list(550 0) "R0")
dbCreateParamInstByMasterName(cv "tphn28hpcpgv18" "PVDD3AC_V_G" "layout" "AVDDH0_bottom_6" list(490 0) "R0")
dbCreateParamInstByMasterName(cv "PAD" "PAD60GU" "layout" "pad60gu_AVDDH0_bottom_6" list(490 0) "R0")
dbCreateParamInstByMasterName(cv "tphn28hpcpgv18" "PDB3AC_V_G" "layout" "VREFN1_bottom_5" list(430 0) "R0")
dbCreateParamInstByMasterName(cv "PAD" "PAD60GU" "layout" "pad60gu_VREFN1_bottom_5" list(430 0) "R0")
dbCreateParamInstByMasterName(cv "tphn28hpcpgv18" "PVDD3AC_V_G" "layout" "VREFP1_bottom_4" list(370 0) "R0")
dbCreateParamInstByMasterName(cv "PAD" "PAD60GU" "layout" "pad60gu_VREFP1_bottom_4" list(370 0) "R0")
dbCreateParamInstByMasterName(cv "tphn28hpcpgv18" "PVSS3AC_V_G" "layout" "AVSS1_bottom_3" list(310 0) "R0")
dbCreateParamInstByMasterName(cv "PAD" "PAD60GU" "layout" "pad60gu_AVSS1_bottom_3" list(310 0) "R0")
dbCreateParamInstByMasterName(cv "tphn28hpcpgv18" "PVSS3AC_V_G" "layout" "AVSS1_bottom_2" list(250 0) "R0")
dbCreateParamInstByMasterName(cv "PAD" "PAD60GU" "layout" "pad60gu_AVSS1_bottom_2" list(250 0) "R0")
dbCreateParamInstByMasterName(cv "tphn28hpcpgv18" "PVDD1AC_V_G" "layout" "AVDDH1_bottom_1" list(190 0) "R0")
dbCreateParamInstByMasterName(cv "PAD" "PAD60GU" "layout" "pad60gu_AVDDH1_bottom_1" list(190 0) "R0")
dbCreateParamInstByMasterName(cv "tphn28hpcpgv18" "PVDD1AC_V_G" "layout" "AVDDH1_bottom_0" list(130 0) "R0")
dbCreateParamInstByMasterName(cv "PAD" "PAD60GU" "layout" "pad60gu_AVDDH1_bottom_0" list(130 0) "R0")
dbCreateParamInstByMasterName(cv "tphn28hpcpgv18" "PCORNERA_G" "layout" "CORNER_BOTTOM_LEFT_bottom_left" list(0 0) "R0")
dbCreateParamInstByMasterName(cv "tphn28hpcpgv18" "PVSS3AC_H_G" "layout" "AVSS3_right_11" list(1780 790) "R90")
dbCreateParamInstByMasterName(cv "PAD" "PAD60GU" "layout" "pad60gu_AVSS3_right_11" list(1780 790) "R90")
dbCreateParamInstByMasterName(cv "tphn28hpcpgv18" "PVDD3AC_H_G" "layout" "AVDDH3_right_10" list(1780 730) "R90")
dbCreateParamInstByMasterName(cv "PAD" "PAD60GU" "layout" "pad60gu_AVDDH3_right_10" list(1780 730) "R90")
dbCreateParamInstByMasterName(cv "tphn28hpcpgv18" "PVDD3AC_H_G" "layout" "AVDDH3_right_9" list(1780 670) "R90")
dbCreateParamInstByMasterName(cv "PAD" "PAD60GU" "layout" "pad60gu_AVDDH3_right_9" list(1780 670) "R90")
dbCreateParamInstByMasterName(cv "tphn28hpcpgv18" "PDB3AC_H_G" "layout" "VREFP3_right_8" list(1780 610) "R90")
dbCreateParamInstByMasterName(cv "PAD" "PAD60GU" "layout" "pad60gu_VREFP3_right_8" list(1780 610) "R90")
dbCreateParamInstByMasterName(cv "tphn28hpcpgv18" "PDB3AC_H_G" "layout" "VREFPF3_right_7" list(1780 550) "R90")
dbCreateParamInstByMasterName(cv "PAD" "PAD60GU" "layout" "pad60gu_VREFPF3_right_7" list(1780 550) "R90")
dbCreateParamInstByMasterName(cv "tphn28hpcpgv18" "PDB3AC_H_G" "layout" "VREFP2_right_6" list(1780 490) "R90")
dbCreateParamInstByMasterName(cv "PAD" "PAD60GU" "layout" "pad60gu_VREFP2_right_6" list(1780 490) "R90")
dbCreateParamInstByMasterName(cv "tphn28hpcpgv18" "PDB3AC_H_G" "layout" "VREFPF2_right_5" list(1780 430) "R90")
dbCreateParamInstByMasterName(cv "PAD" "PAD60GU" "layout" "pad60gu_VREFPF2_right_5" list(1780 430) "R90")
dbCreateParamInstByMasterName(cv "tphn28hpcpgv18" "PDB3AC_H_G" "layout" "IBF_right_4" list(1780 370) "R90")
dbCreateParamInstByMasterName(cv "PAD" "PAD60GU" "layout" "pad60gu_IBF_right_4" list(1780 370) "R90")
dbCreateParamInstByMasterName(cv "tphn28hpcpgv18" "PVDD1AC_H_G" "layout" "CVDD_right_3" list(1780 310) "R90")
dbCreateParamInstByMasterName(cv "PAD" "PAD60GU" "layout" "pad60gu_CVDD_right_3" list(1780 310) "R90")
dbCreateParamInstByMasterName(cv "tphn28hpcpgv18" "PDB3AC_H_G" "layout" "CLKP_right_2" list(1780 250) "R90")
dbCreateParamInstByMasterName(cv "PAD" "PAD60GU" "layout" "pad60gu_CLKP_right_2" list(1780 250) "R90")
dbCreateParamInstByMasterName(cv "tphn28hpcpgv18" "PDB3AC_H_G" "layout" "CLKN_right_1" list(1780 190) "R90")
dbCreateParamInstByMasterName(cv "PAD" "PAD60GU" "layout" "pad60gu_CLKN_right_1" list(1780 190) "R90")
dbCreateParamInstByMasterName(cv "tphn28hpcpgv18" "PVSS1AC_H_G" "layout" "CVSS_right_0" list(1780 130) "R90")
dbCreateParamInstByMasterName(cv "PAD" "PAD60GU" "layout" "pad60gu_CVSS_right_0" list(1780 130) "R90")
dbCreateParamInstByMasterName(cv "tphn28hpcpgv18" "PCORNERA_G" "layout" "CORNER_BOTTOM_RIGHT_bottom_right" list(1780 0) "R90")
dbCreateParamInstByMasterName(cv "tphn28hpcpgv18" "PVSS1AC_V_G" "layout" "VSSFIFO_top_25" list(150 940) "R180")
dbCreateParamInstByMasterName(cv "PAD" "PAD60GU" "layout" "pad60gu_VSSFIFO_top_25" list(150 940) "R180")
dbCreateParamInstByMasterName(cv "tphn28hpcpgv18" "PVDD1AC_V_G" "layout" "VDDFIFO_top_24" list(210 940) "R180")
dbCreateParamInstByMasterName(cv "PAD" "PAD60GU" "layout" "pad60gu_VDDFIFO_top_24" list(210 940) "R180")
dbCreateParamInstByMasterName(cv "tphn28hpcpgv18" "PVSS1AC_V_G" "layout" "VSSSPI_top_23" list(270 940) "R180")
dbCreateParamInstByMasterName(cv "PAD" "PAD60GU" "layout" "pad60gu_VSSSPI_top_23" list(270 940) "R180")
dbCreateParamInstByMasterName(cv "tphn28hpcpgv18" "PVDD1AC_V_G" "layout" "VDDSPI_top_22" list(330 940) "R180")
dbCreateParamInstByMasterName(cv "PAD" "PAD60GU" "layout" "pad60gu_VDDSPI_top_22" list(330 940) "R180")
dbCreateParamInstByMasterName(cv "tphn28hpcpgv18" "PVSS1AC_V_G" "layout" "VSSCAL_top_21" list(390 940) "R180")
dbCreateParamInstByMasterName(cv "PAD" "PAD60GU" "layout" "pad60gu_VSSCAL_top_21" list(390 940) "R180")
dbCreateParamInstByMasterName(cv "tphn28hpcpgv18" "PVDD1AC_V_G" "layout" "VDDCAL_top_20" list(450 940) "R180")
dbCreateParamInstByMasterName(cv "PAD" "PAD60GU" "layout" "pad60gu_VDDCAL_top_20" list(450 940) "R180")
dbCreateParamInstByMasterName(cv "tphn28hpcpgv18" "PVDD1AC_V_G" "layout" "DVDD_top_19" list(510 940) "R180")
dbCreateParamInstByMasterName(cv "PAD" "PAD60GU" "layout" "pad60gu_DVDD_top_19" list(510 940) "R180")
dbCreateParamInstByMasterName(cv "tphn28hpcpgv18" "PVSS1AC_V_G" "layout" "DVSS_top_18" list(570 940) "R180")
dbCreateParamInstByMasterName(cv "PAD" "PAD60GU" "layout" "pad60gu_DVSS_top_18" list(570 940) "R180")
dbCreateParamInstByMasterName(cv "tphn28hpcpgv18" "PDDW16SDGZ_V_G" "layout" "SDI_top_17" list(630 940) "R180")
dbCreateParamInstByMasterName(cv "PAD" "PAD60GU" "layout" "pad60gu_SDI_top_17" list(630 940) "R180")
dbCreateParamInstByMasterName(cv "tphn28hpcpgv18" "PDDW16SDGZ_V_G" "layout" "FLAG_top_16" list(690 940) "R180")
dbCreateParamInstByMasterName(cv "PAD" "PAD60GU" "layout" "pad60gu_FLAG_top_16" list(690 940) "R180")
dbCreateParamInstByMasterName(cv "tphn28hpcpgv18" "PDDW16SDGZ_V_G" "layout" "D_3_top_15" list(750 940) "R180")
dbCreateParamInstByMasterName(cv "PAD" "PAD60GU" "layout" "pad60gu_D_3_top_15" list(750 940) "R180")
dbCreateParamInstByMasterName(cv "tphn28hpcpgv18" "PDDW16SDGZ_V_G" "layout" "D_1_top_14" list(810 940) "R180")
dbCreateParamInstByMasterName(cv "PAD" "PAD60GU" "layout" "pad60gu_D_1_top_14" list(810 940) "R180")
dbCreateParamInstByMasterName(cv "tphn28hpcpgv18" "PDDW16SDGZ_V_G" "layout" "CLKO_top_13" list(870 940) "R180")
dbCreateParamInstByMasterName(cv "PAD" "PAD60GU" "layout" "pad60gu_CLKO_top_13" list(870 940) "R180")
dbCreateParamInstByMasterName(cv "tphn28hpcpgv18" "PDDW16SDGZ_V_G" "layout" "TRIG_top_12" list(930 940) "R180")
dbCreateParamInstByMasterName(cv "PAD" "PAD60GU" "layout" "pad60gu_TRIG_top_12" list(930 940) "R180")
dbCreateParamInstByMasterName(cv "tphn28hpcpgv18" "PDDW16SDGZ_V_G" "layout" "SEL_1_top_11" list(990 940) "R180")
dbCreateParamInstByMasterName(cv "PAD" "PAD60GU" "layout" "pad60gu_SEL_1_top_11" list(990 940) "R180")
dbCreateParamInstByMasterName(cv "tphn28hpcpgv18" "PDDW16SDGZ_V_G" "layout" "SCK_top_10" list(1050 940) "R180")
dbCreateParamInstByMasterName(cv "PAD" "PAD60GU" "layout" "pad60gu_SCK_top_10" list(1050 940) "R180")
dbCreateParamInstByMasterName(cv "tphn28hpcpgv18" "PVDD2POC_V_G" "layout" "VIOH_top_9" list(1110 940) "R180")
dbCreateParamInstByMasterName(cv "PAD" "PAD60GU" "layout" "pad60gu_VIOH_top_9" list(1110 940) "R180")
dbCreateParamInstByMasterName(cv "tphn28hpcpgv18" "PVSS1DGZ_V_G" "layout" "GIOL_top_8" list(1170 940) "R180")
dbCreateParamInstByMasterName(cv "PAD" "PAD60GU" "layout" "pad60gu_GIOL_top_8" list(1170 940) "R180")
dbCreateParamInstByMasterName(cv "tphn28hpcpgv18" "PVSS1AC_V_G" "layout" "DVSS_top_7" list(1230 940) "R180")
dbCreateParamInstByMasterName(cv "PAD" "PAD60GU" "layout" "pad60gu_DVSS_top_7" list(1230 940) "R180")
dbCreateParamInstByMasterName(cv "tphn28hpcpgv18" "PVDD1AC_V_G" "layout" "DVDD_top_6" list(1290 940) "R180")
dbCreateParamInstByMasterName(cv "PAD" "PAD60GU" "layout" "pad60gu_DVDD_top_6" list(1290 940) "R180")
dbCreateParamInstByMasterName(cv "tphn28hpcpgv18" "PVDD1AC_V_G" "layout" "VDDFIFO_top_5" list(1350 940) "R180")
dbCreateParamInstByMasterName(cv "PAD" "PAD60GU" "layout" "pad60gu_VDDFIFO_top_5" list(1350 940) "R180")
dbCreateParamInstByMasterName(cv "tphn28hpcpgv18" "PVSS1AC_V_G" "layout" "VSSFIFO_top_4" list(1410 940) "R180")
dbCreateParamInstByMasterName(cv "PAD" "PAD60GU" "layout" "pad60gu_VSSFIFO_top_4" list(1410 940) "R180")
dbCreateParamInstByMasterName(cv "tphn28hpcpgv18" "PVDD1AC_V_G" "layout" "FVDD_top_3" list(1470 940) "R180")
dbCreateParamInstByMasterName(cv "PAD" "PAD60GU" "layout" "pad60gu_FVDD_top_3" list(1470 940) "R180")
dbCreateParamInstByMasterName(cv "tphn28hpcpgv18" "PVDD1AC_V_G" "layout" "FVDDH_top_2" list(1530 940) "R180")
dbCreateParamInstByMasterName(cv "PAD" "PAD60GU" "layout" "pad60gu_FVDDH_top_2" list(1530 940) "R180")
dbCreateParamInstByMasterName(cv "tphn28hpcpgv18" "PVSS1AC_V_G" "layout" "FVSS_top_1" list(1590 940) "R180")
dbCreateParamInstByMasterName(cv "PAD" "PAD60GU" "layout" "pad60gu_FVSS_top_1" list(1590 940) "R180")
dbCreateParamInstByMasterName(cv "tphn28hpcpgv18" "PVSS3AC_V_G" "layout" "AVSS3_top_0" list(1650 940) "R180")
dbCreateParamInstByMasterName(cv "PAD" "PAD60GU" "layout" "pad60gu_AVSS3_top_0" list(1650 940) "R180")
dbCreateParamInstByMasterName(cv "tphn28hpcpgv18" "PCORNERA_G" "layout" "CORNER_TOP_RIGHT_top_right" list(1780 940) "R180")

; ==================== Inner Ring Pads ====================
dbCreateParamInstByMasterName(cv "tphn28hpcpgv18" "PDB3AC_H_G" "layout" "inner_pad_IBOTA2_left_7_8" list(0 360) "R270")
dbCreateParamInstByMasterName(cv "PAD" "PAD60NU" "layout" "inner_pad60nu_IBOTA2_left_7_8" list(0 360) "R270")
dbCreateParamInstByMasterName(cv "tphn28hpcpgv18" "PDB3AC_H_G" "layout" "inner_pad_VREFPF0_left_8_9" list(0 300) "R270")
dbCreateParamInstByMasterName(cv "PAD" "PAD60NU" "layout" "inner_pad60nu_VREFPF0_left_8_9" list(0 300) "R270")
dbCreateParamInstByMasterName(cv "tphn28hpcpgv18" "PDB3AC_H_G" "layout" "inner_pad_IBOTA0_left_9_10" list(0 240) "R270")
dbCreateParamInstByMasterName(cv "PAD" "PAD60NU" "layout" "inner_pad60nu_IBOTA0_left_9_10" list(0 240) "R270")
dbCreateParamInstByMasterName(cv "tphn28hpcpgv18" "PDB3AC_H_G" "layout" "inner_pad_VREFNF0_left_10_11" list(0 180) "R270")
dbCreateParamInstByMasterName(cv "PAD" "PAD60NU" "layout" "inner_pad60nu_VREFNF0_left_10_11" list(0 180) "R270")
dbCreateParamInstByMasterName(cv "tphn28hpcpgv18" "PDB3AC_H_G" "layout" "inner_pad_VREFNF2_right_4_5" list(1780 400) "R90")
dbCreateParamInstByMasterName(cv "PAD" "PAD60NU" "layout" "inner_pad60nu_VREFNF2_right_4_5" list(1780 400) "R90")
dbCreateParamInstByMasterName(cv "tphn28hpcpgv18" "PDB3AC_H_G" "layout" "inner_pad_VREFN2_right_5_6" list(1780 460) "R90")
dbCreateParamInstByMasterName(cv "PAD" "PAD60NU" "layout" "inner_pad60nu_VREFN2_right_5_6" list(1780 460) "R90")
dbCreateParamInstByMasterName(cv "tphn28hpcpgv18" "PDB3AC_H_G" "layout" "inner_pad_VREFNF3_right_6_7" list(1780 520) "R90")
dbCreateParamInstByMasterName(cv "PAD" "PAD60NU" "layout" "inner_pad60nu_VREFNF3_right_6_7" list(1780 520) "R90")
dbCreateParamInstByMasterName(cv "tphn28hpcpgv18" "PDB3AC_H_G" "layout" "inner_pad_VREFN3_right_7_8" list(1780 580) "R90")
dbCreateParamInstByMasterName(cv "PAD" "PAD60NU" "layout" "inner_pad60nu_VREFN3_right_7_8" list(1780 580) "R90")
dbCreateParamInstByMasterName(cv "tphn28hpcpgv18" "PDB3AC_H_G" "layout" "inner_pad_VREFPF4_left_0_1" list(0 780) "R270")
dbCreateParamInstByMasterName(cv "PAD" "PAD60NU" "layout" "inner_pad60nu_VREFPF4_left_0_1" list(0 780) "R270")
dbCreateParamInstByMasterName(cv "tphn28hpcpgv18" "PDB3AC_H_G" "layout" "inner_pad_VREFNF4_left_1_2" list(0 720) "R270")
dbCreateParamInstByMasterName(cv "PAD" "PAD60NU" "layout" "inner_pad60nu_VREFNF4_left_1_2" list(0 720) "R270")
dbCreateParamInstByMasterName(cv "tphn28hpcpgv18" "PVDD1DGZ_V_G" "layout" "inner_pad_VIOL_top_8_9" list(1140 940) "R180")
dbCreateParamInstByMasterName(cv "PAD" "PAD60NU" "layout" "inner_pad60nu_VIOL_top_8_9" list(1140 940) "R180")
dbCreateParamInstByMasterName(cv "tphn28hpcpgv18" "PVSS2DGZ_V_G" "layout" "inner_pad_GIOH_top_9_10" list(1080 940) "R180")
dbCreateParamInstByMasterName(cv "PAD" "PAD60NU" "layout" "inner_pad60nu_GIOH_top_9_10" list(1080 940) "R180")
dbCreateParamInstByMasterName(cv "tphn28hpcpgv18" "PDDW16SDGZ_V_G" "layout" "inner_pad_SEL_0_top_10_11" list(1020 940) "R180")
dbCreateParamInstByMasterName(cv "PAD" "PAD60NU" "layout" "inner_pad60nu_SEL_0_top_10_11" list(1020 940) "R180")
dbCreateParamInstByMasterName(cv "tphn28hpcpgv18" "PDDW16SDGZ_V_G" "layout" "inner_pad_SEL_2_top_11_12" list(960 940) "R180")
dbCreateParamInstByMasterName(cv "PAD" "PAD60NU" "layout" "inner_pad60nu_SEL_2_top_11_12" list(960 940) "R180")
dbCreateParamInstByMasterName(cv "tphn28hpcpgv18" "PDDW16SDGZ_V_G" "layout" "inner_pad_SDO_top_12_13" list(900 940) "R180")
dbCreateParamInstByMasterName(cv "PAD" "PAD60NU" "layout" "inner_pad60nu_SDO_top_12_13" list(900 940) "R180")
dbCreateParamInstByMasterName(cv "tphn28hpcpgv18" "PDDW16SDGZ_V_G" "layout" "inner_pad_D_0_top_13_14" list(840 940) "R180")
dbCreateParamInstByMasterName(cv "PAD" "PAD60NU" "layout" "inner_pad60nu_D_0_top_13_14" list(840 940) "R180")
dbCreateParamInstByMasterName(cv "tphn28hpcpgv18" "PDDW16SDGZ_V_G" "layout" "inner_pad_D_2_top_14_15" list(780 940) "R180")
dbCreateParamInstByMasterName(cv "PAD" "PAD60NU" "layout" "inner_pad60nu_D_2_top_14_15" list(780 940) "R180")
dbCreateParamInstByMasterName(cv "tphn28hpcpgv18" "PDDW16SDGZ_V_G" "layout" "inner_pad_D_4_top_15_16" list(720 940) "R180")
dbCreateParamInstByMasterName(cv "PAD" "PAD60NU" "layout" "inner_pad60nu_D_4_top_15_16" list(720 940) "R180")
dbCreateParamInstByMasterName(cv "tphn28hpcpgv18" "PDDW16SDGZ_V_G" "layout" "inner_pad_RST_top_16_17" list(660 940) "R180")
dbCreateParamInstByMasterName(cv "PAD" "PAD60NU" "layout" "inner_pad60nu_RST_top_16_17" list(660 940) "R180")
dbCreateParamInstByMasterName(cv "tphn28hpcpgv18" "PDB3AC_V_G" "layout" "inner_pad_VREFPF4_top_20_21" list(420 940) "R180")
dbCreateParamInstByMasterName(cv "PAD" "PAD60NU" "layout" "inner_pad60nu_VREFPF4_top_20_21" list(420 940) "R180")
dbCreateParamInstByMasterName(cv "tphn28hpcpgv18" "PDB3AC_V_G" "layout" "inner_pad_VCM_top_21_22" list(360 940) "R180")
dbCreateParamInstByMasterName(cv "PAD" "PAD60NU" "layout" "inner_pad60nu_VCM_top_21_22" list(360 940) "R180")
dbCreateParamInstByMasterName(cv "tphn28hpcpgv18" "PDB3AC_V_G" "layout" "inner_pad_VREFNF4_top_22_23" list(300 940) "R180")
dbCreateParamInstByMasterName(cv "PAD" "PAD60NU" "layout" "inner_pad60nu_VREFNF4_top_22_23" list(300 940) "R180")

; ==================== Filler Components ====================
dbCreateParamInstByMasterName(cv "tphn28hpcpgv18" "PRCUTA_G" "layout" "sep_bottom_right_corner" list(1650 0) "R0")
dbCreateParamInstByMasterName(cv "tphn28hpcpgv18" "PRCUTA_G" "layout" "filler_bottom_left_corner" list(110 0) "R0")
dbCreateParamInstByMasterName(cv "tphn28hpcpgv18" "PFILLER20A_G" "layout" "filler_R0_1_1" list(1610 0) "R0")
dbCreateParamInstByMasterName(cv "tphn28hpcpgv18" "PFILLER20A_G" "layout" "filler_R0_1_2" list(1590 0) "R0")
dbCreateParamInstByMasterName(cv "tphn28hpcpgv18" "PFILLER20A_G" "layout" "filler_R0_2_1" list(1550 0) "R0")
dbCreateParamInstByMasterName(cv "tphn28hpcpgv18" "PFILLER20A_G" "layout" "filler_R0_2_2" list(1530 0) "R0")
dbCreateParamInstByMasterName(cv "tphn28hpcpgv18" "PFILLER20A_G" "layout" "filler_R0_3_1" list(1490 0) "R0")
dbCreateParamInstByMasterName(cv "tphn28hpcpgv18" "PFILLER20A_G" "layout" "filler_R0_3_2" list(1470 0) "R0")
dbCreateParamInstByMasterName(cv "tphn28hpcpgv18" "PFILLER20A_G" "layout" "filler_R0_4_1" list(1430 0) "R0")
dbCreateParamInstByMasterName(cv "tphn28hpcpgv18" "PFILLER20A_G" "layout" "filler_R0_4_2" list(1410 0) "R0")
dbCreateParamInstByMasterName(cv "tphn28hpcpgv18" "PFILLER20A_G" "layout" "filler_R0_5_1" list(1370 0) "R0")
dbCreateParamInstByMasterName(cv "tphn28hpcpgv18" "PFILLER20A_G" "layout" "filler_R0_5_2" list(1350 0) "R0")
dbCreateParamInstByMasterName(cv "tphn28hpcpgv18" "PRCUTA_G" "layout" "filler_R0_6_1" list(1310 0) "R0")
dbCreateParamInstByMasterName(cv "tphn28hpcpgv18" "PRCUTA_G" "layout" "filler_R0_6_2" list(1290 0) "R0")
dbCreateParamInstByMasterName(cv "tphn28hpcpgv18" "PFILLER20A_G" "layout" "filler_R0_7_1" list(1250 0) "R0")
dbCreateParamInstByMasterName(cv "tphn28hpcpgv18" "PFILLER20A_G" "layout" "filler_R0_7_2" list(1230 0) "R0")
dbCreateParamInstByMasterName(cv "tphn28hpcpgv18" "PFILLER20A_G" "layout" "filler_R0_8_1" list(1190 0) "R0")
dbCreateParamInstByMasterName(cv "tphn28hpcpgv18" "PFILLER20A_G" "layout" "filler_R0_8_2" list(1170 0) "R0")
dbCreateParamInstByMasterName(cv "tphn28hpcpgv18" "PFILLER20A_G" "layout" "filler_R0_9_1" list(1130 0) "R0")
dbCreateParamInstByMasterName(cv "tphn28hpcpgv18" "PFILLER20A_G" "layout" "filler_R0_9_2" list(1110 0) "R0")
dbCreateParamInstByMasterName(cv "tphn28hpcpgv18" "PFILLER20A_G" "layout" "filler_R0_10_1" list(1070 0) "R0")
dbCreateParamInstByMasterName(cv "tphn28hpcpgv18" "PFILLER20A_G" "layout" "filler_R0_10_2" list(1050 0) "R0")
dbCreateParamInstByMasterName(cv "tphn28hpcpgv18" "PFILLER20A_G" "layout" "filler_R0_11_1" list(1010 0) "R0")
dbCreateParamInstByMasterName(cv "tphn28hpcpgv18" "PFILLER20A_G" "layout" "filler_R0_11_2" list(990 0) "R0")
dbCreateParamInstByMasterName(cv "tphn28hpcpgv18" "PFILLER20A_G" "layout" "filler_R0_12_1" list(950 0) "R0")
dbCreateParamInstByMasterName(cv "tphn28hpcpgv18" "PFILLER20A_G" "layout" "filler_R0_12_2" list(930 0) "R0")
dbCreateParamInstByMasterName(cv "tphn28hpcpgv18" "PFILLER20A_G" "layout" "filler_R0_13_1" list(890 0) "R0")
dbCreateParamInstByMasterName(cv "tphn28hpcpgv18" "PFILLER20A_G" "layout" "filler_R0_13_2" list(870 0) "R0")
dbCreateParamInstByMasterName(cv "tphn28hpcpgv18" "PFILLER20A_G" "layout" "filler_R0_14_1" list(830 0) "R0")
dbCreateParamInstByMasterName(cv "tphn28hpcpgv18" "PFILLER20A_G" "layout" "filler_R0_14_2" list(810 0) "R0")
dbCreateParamInstByMasterName(cv "tphn28hpcpgv18" "PFILLER20A_G" "layout" "filler_R0_15_1" list(770 0) "R0")
dbCreateParamInstByMasterName(cv "tphn28hpcpgv18" "PFILLER20A_G" "layout" "filler_R0_15_2" list(750 0) "R0")
dbCreateParamInstByMasterName(cv "tphn28hpcpgv18" "PFILLER20A_G" "layout" "filler_R0_16_1" list(710 0) "R0")
dbCreateParamInstByMasterName(cv "tphn28hpcpgv18" "PFILLER20A_G" "layout" "filler_R0_16_2" list(690 0) "R0")
dbCreateParamInstByMasterName(cv "tphn28hpcpgv18" "PFILLER20A_G" "layout" "filler_R0_17_1" list(650 0) "R0")
dbCreateParamInstByMasterName(cv "tphn28hpcpgv18" "PFILLER20A_G" "layout" "filler_R0_17_2" list(630 0) "R0")
dbCreateParamInstByMasterName(cv "tphn28hpcpgv18" "PFILLER20A_G" "layout" "filler_R0_18_1" list(590 0) "R0")
dbCreateParamInstByMasterName(cv "tphn28hpcpgv18" "PFILLER20A_G" "layout" "filler_R0_18_2" list(570 0) "R0")
dbCreateParamInstByMasterName(cv "tphn28hpcpgv18" "PFILLER20A_G" "layout" "filler_R0_19_1" list(530 0) "R0")
dbCreateParamInstByMasterName(cv "tphn28hpcpgv18" "PFILLER20A_G" "layout" "filler_R0_19_2" list(510 0) "R0")
dbCreateParamInstByMasterName(cv "tphn28hpcpgv18" "PRCUTA_G" "layout" "filler_R0_20_1" list(470 0) "R0")
dbCreateParamInstByMasterName(cv "tphn28hpcpgv18" "PRCUTA_G" "layout" "filler_R0_20_2" list(450 0) "R0")
dbCreateParamInstByMasterName(cv "tphn28hpcpgv18" "PFILLER20A_G" "layout" "filler_R0_21_1" list(410 0) "R0")
dbCreateParamInstByMasterName(cv "tphn28hpcpgv18" "PFILLER20A_G" "layout" "filler_R0_21_2" list(390 0) "R0")
dbCreateParamInstByMasterName(cv "tphn28hpcpgv18" "PFILLER20A_G" "layout" "filler_R0_22_1" list(350 0) "R0")
dbCreateParamInstByMasterName(cv "tphn28hpcpgv18" "PFILLER20A_G" "layout" "filler_R0_22_2" list(330 0) "R0")
dbCreateParamInstByMasterName(cv "tphn28hpcpgv18" "PFILLER20A_G" "layout" "filler_R0_23_1" list(290 0) "R0")
dbCreateParamInstByMasterName(cv "tphn28hpcpgv18" "PFILLER20A_G" "layout" "filler_R0_23_2" list(270 0) "R0")
dbCreateParamInstByMasterName(cv "tphn28hpcpgv18" "PFILLER20A_G" "layout" "filler_R0_24_1" list(230 0) "R0")
dbCreateParamInstByMasterName(cv "tphn28hpcpgv18" "PFILLER20A_G" "layout" "filler_R0_24_2" list(210 0) "R0")
dbCreateParamInstByMasterName(cv "tphn28hpcpgv18" "PFILLER20A_G" "layout" "filler_R0_25_1" list(170 0) "R0")
dbCreateParamInstByMasterName(cv "tphn28hpcpgv18" "PFILLER20A_G" "layout" "filler_R0_25_2" list(150 0) "R0")
dbCreateParamInstByMasterName(cv "tphn28hpcpgv18" "PFILLER20A_G" "layout" "filler_right_top_corner" list(1780 810) "R90")
dbCreateParamInstByMasterName(cv "tphn28hpcpgv18" "PRCUTA_G" "layout" "filler_right_bottom_corner" list(1780 110) "R90")
dbCreateParamInstByMasterName(cv "tphn28hpcpgv18" "PFILLER20A_G" "layout" "filler_R90_1_1" list(1780 770) "R90")
dbCreateParamInstByMasterName(cv "tphn28hpcpgv18" "PFILLER20A_G" "layout" "filler_R90_1_2" list(1780 750) "R90")
dbCreateParamInstByMasterName(cv "tphn28hpcpgv18" "PFILLER20A_G" "layout" "filler_R90_2_1" list(1780 710) "R90")
dbCreateParamInstByMasterName(cv "tphn28hpcpgv18" "PFILLER20A_G" "layout" "filler_R90_2_2" list(1780 690) "R90")
dbCreateParamInstByMasterName(cv "tphn28hpcpgv18" "PFILLER20A_G" "layout" "filler_R90_3_1" list(1780 650) "R90")
dbCreateParamInstByMasterName(cv "tphn28hpcpgv18" "PFILLER20A_G" "layout" "filler_R90_3_2" list(1780 630) "R90")
dbCreateParamInstByMasterName(cv "tphn28hpcpgv18" "PFILLER10A_G" "layout" "filler_R90_4_1" list(1780 600) "R90")
dbCreateParamInstByMasterName(cv "tphn28hpcpgv18" "PFILLER10A_G" "layout" "filler_R90_4_2" list(1780 570) "R90")
dbCreateParamInstByMasterName(cv "tphn28hpcpgv18" "PFILLER10A_G" "layout" "filler_R90_5_1" list(1780 540) "R90")
dbCreateParamInstByMasterName(cv "tphn28hpcpgv18" "PFILLER10A_G" "layout" "filler_R90_5_2" list(1780 510) "R90")
dbCreateParamInstByMasterName(cv "tphn28hpcpgv18" "PFILLER10A_G" "layout" "filler_R90_6_1" list(1780 480) "R90")
dbCreateParamInstByMasterName(cv "tphn28hpcpgv18" "PFILLER10A_G" "layout" "filler_R90_6_2" list(1780 450) "R90")
dbCreateParamInstByMasterName(cv "tphn28hpcpgv18" "PFILLER10A_G" "layout" "filler_R90_7_1" list(1780 420) "R90")
dbCreateParamInstByMasterName(cv "tphn28hpcpgv18" "PFILLER10A_G" "layout" "filler_R90_7_2" list(1780 390) "R90")
dbCreateParamInstByMasterName(cv "tphn28hpcpgv18" "PFILLER20A_G" "layout" "filler_R90_8_1" list(1780 350) "R90")
dbCreateParamInstByMasterName(cv "tphn28hpcpgv18" "PFILLER20A_G" "layout" "filler_R90_8_2" list(1780 330) "R90")
dbCreateParamInstByMasterName(cv "tphn28hpcpgv18" "PFILLER20A_G" "layout" "filler_R90_9_1" list(1780 290) "R90")
dbCreateParamInstByMasterName(cv "tphn28hpcpgv18" "PFILLER20A_G" "layout" "filler_R90_9_2" list(1780 270) "R90")
dbCreateParamInstByMasterName(cv "tphn28hpcpgv18" "PFILLER20A_G" "layout" "filler_R90_10_1" list(1780 230) "R90")
dbCreateParamInstByMasterName(cv "tphn28hpcpgv18" "PFILLER20A_G" "layout" "filler_R90_10_2" list(1780 210) "R90")
dbCreateParamInstByMasterName(cv "tphn28hpcpgv18" "PFILLER20A_G" "layout" "filler_R90_11_1" list(1780 170) "R90")
dbCreateParamInstByMasterName(cv "tphn28hpcpgv18" "PFILLER20A_G" "layout" "filler_R90_11_2" list(1780 150) "R90")
dbCreateParamInstByMasterName(cv "tphn28hpcpgv18" "PFILLER20A_G" "layout" "sep_top_left_corner" list(130 940) "R180")
dbCreateParamInstByMasterName(cv "tphn28hpcpgv18" "PFILLER20A_G" "layout" "filler_top_right_corner" list(1670 940) "R180")
dbCreateParamInstByMasterName(cv "tphn28hpcpgv18" "PFILLER20A_G" "layout" "filler_R180_1_1" list(170 940) "R180")
dbCreateParamInstByMasterName(cv "tphn28hpcpgv18" "PFILLER20A_G" "layout" "filler_R180_1_2" list(190 940) "R180")
dbCreateParamInstByMasterName(cv "tphn28hpcpgv18" "PFILLER20A_G" "layout" "filler_R180_2_1" list(230 940) "R180")
dbCreateParamInstByMasterName(cv "tphn28hpcpgv18" "PFILLER20A_G" "layout" "filler_R180_2_2" list(250 940) "R180")
dbCreateParamInstByMasterName(cv "tphn28hpcpgv18" "PFILLER10A_G" "layout" "filler_R180_3_1" list(280 940) "R180")
dbCreateParamInstByMasterName(cv "tphn28hpcpgv18" "PFILLER10A_G" "layout" "filler_R180_3_2" list(310 940) "R180")
dbCreateParamInstByMasterName(cv "tphn28hpcpgv18" "PFILLER10A_G" "layout" "filler_R180_4_1" list(340 940) "R180")
dbCreateParamInstByMasterName(cv "tphn28hpcpgv18" "PFILLER10A_G" "layout" "filler_R180_4_2" list(370 940) "R180")
dbCreateParamInstByMasterName(cv "tphn28hpcpgv18" "PFILLER10A_G" "layout" "filler_R180_5_1" list(400 940) "R180")
dbCreateParamInstByMasterName(cv "tphn28hpcpgv18" "PFILLER10A_G" "layout" "filler_R180_5_2" list(430 940) "R180")
dbCreateParamInstByMasterName(cv "tphn28hpcpgv18" "PFILLER20A_G" "layout" "filler_R180_6_1" list(470 940) "R180")
dbCreateParamInstByMasterName(cv "tphn28hpcpgv18" "PFILLER20A_G" "layout" "filler_R180_6_2" list(490 940) "R180")
dbCreateParamInstByMasterName(cv "tphn28hpcpgv18" "PFILLER20A_G" "layout" "filler_R180_7_1" list(530 940) "R180")
dbCreateParamInstByMasterName(cv "tphn28hpcpgv18" "PFILLER20A_G" "layout" "filler_R180_7_2" list(550 940) "R180")
dbCreateParamInstByMasterName(cv "tphn28hpcpgv18" "PRCUTA_G" "layout" "filler_R180_8_1" list(590 940) "R180")
dbCreateParamInstByMasterName(cv "tphn28hpcpgv18" "PRCUTA_G" "layout" "filler_R180_8_2" list(610 940) "R180")
dbCreateParamInstByMasterName(cv "tphn28hpcpgv18" "PFILLER10_G" "layout" "filler_R180_9_1" list(640 940) "R180")
dbCreateParamInstByMasterName(cv "tphn28hpcpgv18" "PFILLER10_G" "layout" "filler_R180_9_2" list(670 940) "R180")
dbCreateParamInstByMasterName(cv "tphn28hpcpgv18" "PFILLER10_G" "layout" "filler_R180_10_1" list(700 940) "R180")
dbCreateParamInstByMasterName(cv "tphn28hpcpgv18" "PFILLER10_G" "layout" "filler_R180_10_2" list(730 940) "R180")
dbCreateParamInstByMasterName(cv "tphn28hpcpgv18" "PFILLER10_G" "layout" "filler_R180_11_1" list(760 940) "R180")
dbCreateParamInstByMasterName(cv "tphn28hpcpgv18" "PFILLER10_G" "layout" "filler_R180_11_2" list(790 940) "R180")
dbCreateParamInstByMasterName(cv "tphn28hpcpgv18" "PFILLER10_G" "layout" "filler_R180_12_1" list(820 940) "R180")
dbCreateParamInstByMasterName(cv "tphn28hpcpgv18" "PFILLER10_G" "layout" "filler_R180_12_2" list(850 940) "R180")
dbCreateParamInstByMasterName(cv "tphn28hpcpgv18" "PFILLER10_G" "layout" "filler_R180_13_1" list(880 940) "R180")
dbCreateParamInstByMasterName(cv "tphn28hpcpgv18" "PFILLER10_G" "layout" "filler_R180_13_2" list(910 940) "R180")
dbCreateParamInstByMasterName(cv "tphn28hpcpgv18" "PFILLER10_G" "layout" "filler_R180_14_1" list(940 940) "R180")
dbCreateParamInstByMasterName(cv "tphn28hpcpgv18" "PFILLER10_G" "layout" "filler_R180_14_2" list(970 940) "R180")
dbCreateParamInstByMasterName(cv "tphn28hpcpgv18" "PFILLER10_G" "layout" "filler_R180_15_1" list(1000 940) "R180")
dbCreateParamInstByMasterName(cv "tphn28hpcpgv18" "PFILLER10_G" "layout" "filler_R180_15_2" list(1030 940) "R180")
dbCreateParamInstByMasterName(cv "tphn28hpcpgv18" "PFILLER10_G" "layout" "filler_R180_16_1" list(1060 940) "R180")
dbCreateParamInstByMasterName(cv "tphn28hpcpgv18" "PFILLER10_G" "layout" "filler_R180_16_2" list(1090 940) "R180")
dbCreateParamInstByMasterName(cv "tphn28hpcpgv18" "PFILLER10_G" "layout" "filler_R180_17_1" list(1120 940) "R180")
dbCreateParamInstByMasterName(cv "tphn28hpcpgv18" "PFILLER10_G" "layout" "filler_R180_17_2" list(1150 940) "R180")
dbCreateParamInstByMasterName(cv "tphn28hpcpgv18" "PRCUTA_G" "layout" "filler_R180_18_1" list(1190 940) "R180")
dbCreateParamInstByMasterName(cv "tphn28hpcpgv18" "PRCUTA_G" "layout" "filler_R180_18_2" list(1210 940) "R180")
dbCreateParamInstByMasterName(cv "tphn28hpcpgv18" "PFILLER20A_G" "layout" "filler_R180_19_1" list(1250 940) "R180")
dbCreateParamInstByMasterName(cv "tphn28hpcpgv18" "PFILLER20A_G" "layout" "filler_R180_19_2" list(1270 940) "R180")
dbCreateParamInstByMasterName(cv "tphn28hpcpgv18" "PFILLER20A_G" "layout" "filler_R180_20_1" list(1310 940) "R180")
dbCreateParamInstByMasterName(cv "tphn28hpcpgv18" "PFILLER20A_G" "layout" "filler_R180_20_2" list(1330 940) "R180")
dbCreateParamInstByMasterName(cv "tphn28hpcpgv18" "PFILLER20A_G" "layout" "filler_R180_21_1" list(1370 940) "R180")
dbCreateParamInstByMasterName(cv "tphn28hpcpgv18" "PFILLER20A_G" "layout" "filler_R180_21_2" list(1390 940) "R180")
dbCreateParamInstByMasterName(cv "tphn28hpcpgv18" "PFILLER20A_G" "layout" "filler_R180_22_1" list(1430 940) "R180")
dbCreateParamInstByMasterName(cv "tphn28hpcpgv18" "PFILLER20A_G" "layout" "filler_R180_22_2" list(1450 940) "R180")
dbCreateParamInstByMasterName(cv "tphn28hpcpgv18" "PFILLER20A_G" "layout" "filler_R180_23_1" list(1490 940) "R180")
dbCreateParamInstByMasterName(cv "tphn28hpcpgv18" "PFILLER20A_G" "layout" "filler_R180_23_2" list(1510 940) "R180")
dbCreateParamInstByMasterName(cv "tphn28hpcpgv18" "PFILLER20A_G" "layout" "filler_R180_24_1" list(1550 940) "R180")
dbCreateParamInstByMasterName(cv "tphn28hpcpgv18" "PFILLER20A_G" "layout" "filler_R180_24_2" list(1570 940) "R180")
dbCreateParamInstByMasterName(cv "tphn28hpcpgv18" "PFILLER20A_G" "layout" "filler_R180_25_1" list(1610 940) "R180")
dbCreateParamInstByMasterName(cv "tphn28hpcpgv18" "PFILLER20A_G" "layout" "filler_R180_25_2" list(1630 940) "R180")
dbCreateParamInstByMasterName(cv "tphn28hpcpgv18" "PRCUTA_G" "layout" "filler_left_bottom_corner" list(0 130) "R270")
dbCreateParamInstByMasterName(cv "tphn28hpcpgv18" "PFILLER20A_G" "layout" "sep_left_top_corner" list(0 830) "R270")
dbCreateParamInstByMasterName(cv "tphn28hpcpgv18" "PFILLER10A_G" "layout" "filler_R270_1_1" list(0 160) "R270")
dbCreateParamInstByMasterName(cv "tphn28hpcpgv18" "PFILLER10A_G" "layout" "filler_R270_1_2" list(0 190) "R270")
dbCreateParamInstByMasterName(cv "tphn28hpcpgv18" "PFILLER10A_G" "layout" "filler_R270_2_1" list(0 220) "R270")
dbCreateParamInstByMasterName(cv "tphn28hpcpgv18" "PFILLER10A_G" "layout" "filler_R270_2_2" list(0 250) "R270")
dbCreateParamInstByMasterName(cv "tphn28hpcpgv18" "PFILLER10A_G" "layout" "filler_R270_3_1" list(0 280) "R270")
dbCreateParamInstByMasterName(cv "tphn28hpcpgv18" "PFILLER10A_G" "layout" "filler_R270_3_2" list(0 310) "R270")
dbCreateParamInstByMasterName(cv "tphn28hpcpgv18" "PFILLER10A_G" "layout" "filler_R270_4_1" list(0 340) "R270")
dbCreateParamInstByMasterName(cv "tphn28hpcpgv18" "PFILLER10A_G" "layout" "filler_R270_4_2" list(0 370) "R270")
dbCreateParamInstByMasterName(cv "tphn28hpcpgv18" "PFILLER20A_G" "layout" "filler_R270_5_1" list(0 410) "R270")
dbCreateParamInstByMasterName(cv "tphn28hpcpgv18" "PFILLER20A_G" "layout" "filler_R270_5_2" list(0 430) "R270")
dbCreateParamInstByMasterName(cv "tphn28hpcpgv18" "PFILLER20A_G" "layout" "filler_R270_6_1" list(0 470) "R270")
dbCreateParamInstByMasterName(cv "tphn28hpcpgv18" "PFILLER20A_G" "layout" "filler_R270_6_2" list(0 490) "R270")
dbCreateParamInstByMasterName(cv "tphn28hpcpgv18" "PFILLER20A_G" "layout" "filler_R270_7_1" list(0 530) "R270")
dbCreateParamInstByMasterName(cv "tphn28hpcpgv18" "PFILLER20A_G" "layout" "filler_R270_7_2" list(0 550) "R270")
dbCreateParamInstByMasterName(cv "tphn28hpcpgv18" "PFILLER20A_G" "layout" "filler_R270_8_1" list(0 590) "R270")
dbCreateParamInstByMasterName(cv "tphn28hpcpgv18" "PFILLER20A_G" "layout" "filler_R270_8_2" list(0 610) "R270")
dbCreateParamInstByMasterName(cv "tphn28hpcpgv18" "PFILLER20A_G" "layout" "filler_R270_9_1" list(0 650) "R270")
dbCreateParamInstByMasterName(cv "tphn28hpcpgv18" "PFILLER20A_G" "layout" "filler_R270_9_2" list(0 670) "R270")
dbCreateParamInstByMasterName(cv "tphn28hpcpgv18" "PFILLER10A_G" "layout" "filler_R270_10_1" list(0 700) "R270")
dbCreateParamInstByMasterName(cv "tphn28hpcpgv18" "PFILLER10A_G" "layout" "filler_R270_10_2" list(0 730) "R270")
dbCreateParamInstByMasterName(cv "tphn28hpcpgv18" "PFILLER10A_G" "layout" "filler_R270_11_1" list(0 760) "R270")
dbCreateParamInstByMasterName(cv "tphn28hpcpgv18" "PFILLER10A_G" "layout" "filler_R270_11_2" list(0 790) "R270")

; ==================== Digital IO Features (with Inner Pad Support) ====================
dbCreatePath(cv list("M3" "drawing") list(list(610 829.5) list(1170 829.5)) 0.2)
dbCreatePath(cv list("M3" "drawing") list(list(610 830.76) list(1170 830.76)) 0.2)
dbCreatePath(cv list("M3" "drawing") list(list(1167.61 829.88) list(1167.61 830.76)) 0.2)
tech = techGetTechFile(cv)
viaParams = list(list("cutRows" 2) list("cutColumns" 4))
viaDefId = techFindViaDefByName(tech "M3_M2")
newVia = dbCreateVia(cv viaDefId list(1167.61 829.88) "R180" viaParams)
dbCreatePath(cv list("M3" "drawing") list(list(1137.655 829.88) list(1137.655 829.5)) 0.2)
tech = techGetTechFile(cv)
viaParams = list(list("cutRows" 2) list("cutColumns" 4))
viaDefId = techFindViaDefByName(tech "M3_M2")
newVia = dbCreateVia(cv viaDefId list(1137.655 829.88) "R180" viaParams)
dbCreatePath(cv list("M3" "drawing") list(list(1039.8 830.125) list(1039.8 830.76)) 0.26)
dbCreatePath(cv list("M3" "drawing") list(list(1048.275 830.125) list(1048.275 830.76)) 0.26)
dbCreatePath(cv list("M3" "drawing") list(list(1044.1 830.125) list(1044.1 829.5)) 0.26)
dbCreateLabel(cv list("M4" "pin") list(1035.67 830.125) "SCK_CORE" "centerRight" "R90" "roman" 2)
dbCreatePath(cv list("M3" "drawing") list(list(979.8 830.125) list(979.8 830.76)) 0.26)
dbCreatePath(cv list("M3" "drawing") list(list(988.275 830.125) list(988.275 830.76)) 0.26)
dbCreatePath(cv list("M3" "drawing") list(list(984.1 830.125) list(984.1 829.5)) 0.26)
dbCreateLabel(cv list("M4" "pin") list(975.67 830.125) "SEL_CORE<1>" "centerRight" "R90" "roman" 2)
dbCreatePath(cv list("M3" "drawing") list(list(919.8 830.125) list(919.8 830.76)) 0.26)
dbCreatePath(cv list("M3" "drawing") list(list(928.275 830.125) list(928.275 830.76)) 0.26)
dbCreatePath(cv list("M3" "drawing") list(list(924.1 830.125) list(924.1 829.5)) 0.26)
dbCreateLabel(cv list("M4" "pin") list(915.67 830.125) "TRIG_CORE" "centerRight" "R90" "roman" 2)
dbCreatePath(cv list("M3" "drawing") list(list(859.8 830.125) list(859.8 829.5)) 0.26)
dbCreatePath(cv list("M3" "drawing") list(list(864.1 830.125) list(864.1 830.76)) 0.26)
dbCreateLabel(cv list("M4" "pin") list(868.275 830.125) "CLKO_CORE" "centerRight" "R90" "roman" 2)
dbCreatePath(cv list("M3" "drawing") list(list(799.8 830.125) list(799.8 829.5)) 0.26)
dbCreatePath(cv list("M3" "drawing") list(list(804.1 830.125) list(804.1 830.76)) 0.26)
dbCreateLabel(cv list("M4" "pin") list(808.275 830.125) "D_CORE<1>" "centerRight" "R90" "roman" 2)
dbCreatePath(cv list("M3" "drawing") list(list(739.8 830.125) list(739.8 829.5)) 0.26)
dbCreatePath(cv list("M3" "drawing") list(list(744.1 830.125) list(744.1 830.76)) 0.26)
dbCreateLabel(cv list("M4" "pin") list(748.275 830.125) "D_CORE<3>" "centerRight" "R90" "roman" 2)
dbCreatePath(cv list("M3" "drawing") list(list(679.8 830.125) list(679.8 829.5)) 0.26)
dbCreatePath(cv list("M3" "drawing") list(list(684.1 830.125) list(684.1 830.76)) 0.26)
dbCreateLabel(cv list("M4" "pin") list(688.275 830.125) "FLAG_CORE" "centerRight" "R90" "roman" 2)
dbCreatePath(cv list("M3" "drawing") list(list(619.8 830.125) list(619.8 830.76)) 0.26)
dbCreatePath(cv list("M3" "drawing") list(list(628.275 830.125) list(628.275 830.76)) 0.26)
dbCreatePath(cv list("M3" "drawing") list(list(624.1 830.125) list(624.1 829.5)) 0.26)
dbCreateLabel(cv list("M4" "pin") list(615.67 830.125) "SDI_CORE" "centerRight" "R90" "roman" 2)
dbCreatePath(cv list("M3" "drawing") list(list(1009.8 830.125) list(1009.8 830.76)) 0.26)
dbCreatePath(cv list("M3" "drawing") list(list(1018.275 830.125) list(1018.275 830.76)) 0.26)
dbCreatePath(cv list("M3" "drawing") list(list(1014.1 830.125) list(1014.1 829.5)) 0.26)
dbCreateLabel(cv list("M4" "pin") list(1005.67 830.125) "SEL_CORE<0>" "centerRight" "R90" "roman" 2)
dbCreatePath(cv list("M3" "drawing") list(list(949.8 830.125) list(949.8 830.76)) 0.26)
dbCreatePath(cv list("M3" "drawing") list(list(958.275 830.125) list(958.275 830.76)) 0.26)
dbCreatePath(cv list("M3" "drawing") list(list(954.1 830.125) list(954.1 829.5)) 0.26)
dbCreateLabel(cv list("M4" "pin") list(945.67 830.125) "SEL_CORE<2>" "centerRight" "R90" "roman" 2)
dbCreatePath(cv list("M3" "drawing") list(list(889.8 830.125) list(889.8 829.5)) 0.26)
dbCreatePath(cv list("M3" "drawing") list(list(894.1 830.125) list(894.1 830.76)) 0.26)
dbCreateLabel(cv list("M4" "pin") list(898.275 830.125) "SDO_CORE" "centerRight" "R90" "roman" 2)
dbCreatePath(cv list("M3" "drawing") list(list(829.8 830.125) list(829.8 829.5)) 0.26)
dbCreatePath(cv list("M3" "drawing") list(list(834.1 830.125) list(834.1 830.76)) 0.26)
dbCreateLabel(cv list("M4" "pin") list(838.275 830.125) "D_CORE<0>" "centerRight" "R90" "roman" 2)
dbCreatePath(cv list("M3" "drawing") list(list(769.8 830.125) list(769.8 829.5)) 0.26)
dbCreatePath(cv list("M3" "drawing") list(list(774.1 830.125) list(774.1 830.76)) 0.26)
dbCreateLabel(cv list("M4" "pin") list(778.275 830.125) "D_CORE<2>" "centerRight" "R90" "roman" 2)
dbCreatePath(cv list("M3" "drawing") list(list(709.8 830.125) list(709.8 829.5)) 0.26)
dbCreatePath(cv list("M3" "drawing") list(list(714.1 830.125) list(714.1 830.76)) 0.26)
dbCreateLabel(cv list("M4" "pin") list(718.275 830.125) "D_CORE<4>" "centerRight" "R90" "roman" 2)
dbCreatePath(cv list("M3" "drawing") list(list(649.8 830.125) list(649.8 830.76)) 0.26)
dbCreatePath(cv list("M3" "drawing") list(list(658.275 830.125) list(658.275 830.76)) 0.26)
dbCreatePath(cv list("M3" "drawing") list(list(654.1 830.125) list(654.1 829.5)) 0.26)
dbCreateLabel(cv list("M4" "pin") list(645.67 830.125) "RST_CORE" "centerRight" "R90" "roman" 2)

; ==================== Pin Labels (with Inner Pad Support) ====================
dbCreateLabel(cv list("AP" "pin") list(-11 800) "AVSS2" "centerRight" "R0" "roman" 10)
dbCreateLabel(cv list("M2" "pin") list(109.9 800) "AVSS2_CORE" "centerLeft" "R0" "roman" 2)
dbCreateLabel(cv list("AP" "pin") list(-11 740) "AVSS2" "centerRight" "R0" "roman" 10)
dbCreateLabel(cv list("M2" "pin") list(109.9 740) "AVSS2_CORE" "centerLeft" "R0" "roman" 2)
dbCreateLabel(cv list("AP" "pin") list(-11 680) "AVDDH2" "centerRight" "R0" "roman" 10)
dbCreateLabel(cv list("M2" "pin") list(109.9 680) "AVDDH2_CORE" "centerLeft" "R0" "roman" 2)
dbCreateLabel(cv list("AP" "pin") list(-11 620) "AVDDH2" "centerRight" "R0" "roman" 10)
dbCreateLabel(cv list("M2" "pin") list(109.9 620) "AVDDH2_CORE" "centerLeft" "R0" "roman" 2)
dbCreateLabel(cv list("AP" "pin") list(-11 560) "FVDD" "centerRight" "R0" "roman" 10)
dbCreateLabel(cv list("AP" "pin") list(-11 500) "FVDDH" "centerRight" "R0" "roman" 10)
dbCreateLabel(cv list("AP" "pin") list(-11 440) "FVSS" "centerRight" "R0" "roman" 10)
dbCreateLabel(cv list("AP" "pin") list(-11 380) "IBOTA3" "centerRight" "R0" "roman" 10)
dbCreateLabel(cv list("AP" "pin") list(-11 320) "IBOTA1" "centerRight" "R0" "roman" 10)
dbCreateLabel(cv list("AP" "pin") list(-11 260) "VREFNF1" "centerRight" "R0" "roman" 10)
dbCreateLabel(cv list("AP" "pin") list(-11 200) "VREFPF0" "centerRight" "R0" "roman" 10)
dbCreateLabel(cv list("AP" "pin") list(-11 140) "VCM" "centerRight" "R0" "roman" 10)
dbCreateLabel(cv list("AP" "pin") list(140 -11) "AVDDH1" "centerRight" "R90" "roman" 10)
dbCreateLabel(cv list("AP" "pin") list(200 -11) "AVDDH1" "centerRight" "R90" "roman" 10)
dbCreateLabel(cv list("AP" "pin") list(260 -11) "AVSS1" "centerRight" "R90" "roman" 10)
dbCreateLabel(cv list("M2" "pin") list(260 109.9) "AVSS1_CORE" "centerLeft" "R90" "roman" 2)
dbCreateLabel(cv list("AP" "pin") list(320 -11) "AVSS1" "centerRight" "R90" "roman" 10)
dbCreateLabel(cv list("M2" "pin") list(320 109.9) "AVSS1_CORE" "centerLeft" "R90" "roman" 2)
dbCreateLabel(cv list("AP" "pin") list(380 -11) "VREFP1" "centerRight" "R90" "roman" 10)
dbCreateLabel(cv list("M2" "pin") list(380 109.9) "VREFP1_CORE" "centerLeft" "R90" "roman" 2)
dbCreateLabel(cv list("AP" "pin") list(440 -11) "VREFN1" "centerRight" "R90" "roman" 10)
dbCreateLabel(cv list("AP" "pin") list(500 -11) "AVDDH0" "centerRight" "R90" "roman" 10)
dbCreateLabel(cv list("M2" "pin") list(500 109.9) "AVDDH0_CORE" "centerLeft" "R90" "roman" 2)
dbCreateLabel(cv list("AP" "pin") list(560 -11) "AVDDH0" "centerRight" "R90" "roman" 10)
dbCreateLabel(cv list("M2" "pin") list(560 109.9) "AVDDH0_CORE" "centerLeft" "R90" "roman" 2)
dbCreateLabel(cv list("AP" "pin") list(620 -11) "AVSS0" "centerRight" "R90" "roman" 10)
dbCreateLabel(cv list("M2" "pin") list(620 109.9) "AVSS0_CORE" "centerLeft" "R90" "roman" 2)
dbCreateLabel(cv list("AP" "pin") list(680 -11) "AVSS0" "centerRight" "R90" "roman" 10)
dbCreateLabel(cv list("M2" "pin") list(680 109.9) "AVSS0_CORE" "centerLeft" "R90" "roman" 2)
dbCreateLabel(cv list("AP" "pin") list(740 -11) "VREFP0" "centerRight" "R90" "roman" 10)
dbCreateLabel(cv list("AP" "pin") list(800 -11) "VREFN0" "centerRight" "R90" "roman" 10)
dbCreateLabel(cv list("AP" "pin") list(860 -11) "VINP" "centerRight" "R90" "roman" 10)
dbCreateLabel(cv list("AP" "pin") list(920 -11) "VINN" "centerRight" "R90" "roman" 10)
dbCreateLabel(cv list("AP" "pin") list(980 -11) "VREFN0" "centerRight" "R90" "roman" 10)
dbCreateLabel(cv list("AP" "pin") list(1040 -11) "VREFP0" "centerRight" "R90" "roman" 10)
dbCreateLabel(cv list("AP" "pin") list(1100 -11) "AVSS0" "centerRight" "R90" "roman" 10)
dbCreateLabel(cv list("M2" "pin") list(1100 109.9) "AVSS0_CORE" "centerLeft" "R90" "roman" 2)
dbCreateLabel(cv list("AP" "pin") list(1160 -11) "AVSS0" "centerRight" "R90" "roman" 10)
dbCreateLabel(cv list("M2" "pin") list(1160 109.9) "AVSS0_CORE" "centerLeft" "R90" "roman" 2)
dbCreateLabel(cv list("AP" "pin") list(1220 -11) "AVDDH0" "centerRight" "R90" "roman" 10)
dbCreateLabel(cv list("M2" "pin") list(1220 109.9) "AVDDH0_CORE" "centerLeft" "R90" "roman" 2)
dbCreateLabel(cv list("AP" "pin") list(1280 -11) "AVDDH0" "centerRight" "R90" "roman" 10)
dbCreateLabel(cv list("M2" "pin") list(1280 109.9) "AVDDH0_CORE" "centerLeft" "R90" "roman" 2)
dbCreateLabel(cv list("AP" "pin") list(1340 -11) "VREFN1" "centerRight" "R90" "roman" 10)
dbCreateLabel(cv list("AP" "pin") list(1400 -11) "VREFP1" "centerRight" "R90" "roman" 10)
dbCreateLabel(cv list("M2" "pin") list(1400 109.9) "VREFP1_CORE" "centerLeft" "R90" "roman" 2)
dbCreateLabel(cv list("AP" "pin") list(1460 -11) "AVSS1" "centerRight" "R90" "roman" 10)
dbCreateLabel(cv list("M2" "pin") list(1460 109.9) "AVSS1_CORE" "centerLeft" "R90" "roman" 2)
dbCreateLabel(cv list("AP" "pin") list(1520 -11) "AVSS1" "centerRight" "R90" "roman" 10)
dbCreateLabel(cv list("M2" "pin") list(1520 109.9) "AVSS1_CORE" "centerLeft" "R90" "roman" 2)
dbCreateLabel(cv list("AP" "pin") list(1580 -11) "AVDDH1" "centerRight" "R90" "roman" 10)
dbCreateLabel(cv list("AP" "pin") list(1640 -11) "AVDDH1" "centerRight" "R90" "roman" 10)
dbCreateLabel(cv list("AP" "pin") list(1791 140) "CVSS" "centerLeft" "R0" "roman" 10)
dbCreateLabel(cv list("AP" "pin") list(1791 200) "CLKN" "centerLeft" "R0" "roman" 10)
dbCreateLabel(cv list("AP" "pin") list(1791 260) "CLKP" "centerLeft" "R0" "roman" 10)
dbCreateLabel(cv list("AP" "pin") list(1791 320) "CVDD" "centerLeft" "R0" "roman" 10)
dbCreateLabel(cv list("AP" "pin") list(1791 380) "IBF" "centerLeft" "R0" "roman" 10)
dbCreateLabel(cv list("AP" "pin") list(1791 440) "VREFPF2" "centerLeft" "R0" "roman" 10)
dbCreateLabel(cv list("AP" "pin") list(1791 500) "VREFP2" "centerLeft" "R0" "roman" 10)
dbCreateLabel(cv list("AP" "pin") list(1791 560) "VREFPF3" "centerLeft" "R0" "roman" 10)
dbCreateLabel(cv list("AP" "pin") list(1791 620) "VREFP3" "centerLeft" "R0" "roman" 10)
dbCreateLabel(cv list("AP" "pin") list(1791 680) "AVDDH3" "centerLeft" "R0" "roman" 10)
dbCreateLabel(cv list("M2" "pin") list(1670.1 680) "AVDDH3_CORE" "centerRight" "R0" "roman" 2)
dbCreateLabel(cv list("AP" "pin") list(1791 740) "AVDDH3" "centerLeft" "R0" "roman" 10)
dbCreateLabel(cv list("M2" "pin") list(1670.1 740) "AVDDH3_CORE" "centerRight" "R0" "roman" 2)
dbCreateLabel(cv list("AP" "pin") list(1791 800) "AVSS3" "centerLeft" "R0" "roman" 10)
dbCreateLabel(cv list("M2" "pin") list(1670.1 800) "AVSS3_CORE" "centerRight" "R0" "roman" 2)
dbCreateLabel(cv list("AP" "pin") list(1640 951) "AVSS3" "centerLeft" "R90" "roman" 10)
dbCreateLabel(cv list("M2" "pin") list(1640 830.1) "AVSS3_CORE" "centerRight" "R90" "roman" 2)
dbCreateLabel(cv list("AP" "pin") list(1580 951) "FVSS" "centerLeft" "R90" "roman" 10)
dbCreateLabel(cv list("AP" "pin") list(1520 951) "FVDDH" "centerLeft" "R90" "roman" 10)
dbCreateLabel(cv list("AP" "pin") list(1460 951) "FVDD" "centerLeft" "R90" "roman" 10)
dbCreateLabel(cv list("AP" "pin") list(1400 951) "VSSFIFO" "centerLeft" "R90" "roman" 10)
dbCreateLabel(cv list("AP" "pin") list(1340 951) "VDDFIFO" "centerLeft" "R90" "roman" 10)
dbCreateLabel(cv list("AP" "pin") list(1280 951) "DVDD" "centerLeft" "R90" "roman" 10)
dbCreateLabel(cv list("AP" "pin") list(1220 951) "DVSS" "centerLeft" "R90" "roman" 10)
dbCreateLabel(cv list("AP" "pin") list(1160 951) "GIOL" "centerLeft" "R90" "roman" 10)
dbCreateLabel(cv list("AP" "pin") list(1100 951) "VIOH" "centerLeft" "R90" "roman" 10)
dbCreateLabel(cv list("AP" "pin") list(1040 951) "SCK" "centerLeft" "R90" "roman" 10)
dbCreateLabel(cv list("AP" "pin") list(980 951) "SEL<1>" "centerLeft" "R90" "roman" 10)
dbCreateLabel(cv list("AP" "pin") list(920 951) "TRIG" "centerLeft" "R90" "roman" 10)
dbCreateLabel(cv list("AP" "pin") list(860 951) "CLKO" "centerLeft" "R90" "roman" 10)
dbCreateLabel(cv list("AP" "pin") list(800 951) "D<1>" "centerLeft" "R90" "roman" 10)
dbCreateLabel(cv list("AP" "pin") list(740 951) "D<3>" "centerLeft" "R90" "roman" 10)
dbCreateLabel(cv list("AP" "pin") list(680 951) "FLAG" "centerLeft" "R90" "roman" 10)
dbCreateLabel(cv list("AP" "pin") list(620 951) "SDI" "centerLeft" "R90" "roman" 10)
dbCreateLabel(cv list("AP" "pin") list(560 951) "DVSS" "centerLeft" "R90" "roman" 10)
dbCreateLabel(cv list("AP" "pin") list(500 951) "DVDD" "centerLeft" "R90" "roman" 10)
dbCreateLabel(cv list("AP" "pin") list(440 951) "VDDCAL" "centerLeft" "R90" "roman" 10)
dbCreateLabel(cv list("AP" "pin") list(380 951) "VSSCAL" "centerLeft" "R90" "roman" 10)
dbCreateLabel(cv list("AP" "pin") list(320 951) "VDDSPI" "centerLeft" "R90" "roman" 10)
dbCreateLabel(cv list("AP" "pin") list(260 951) "VSSSPI" "centerLeft" "R90" "roman" 10)
dbCreateLabel(cv list("AP" "pin") list(200 951) "VDDFIFO" "centerLeft" "R90" "roman" 10)
dbCreateLabel(cv list("AP" "pin") list(140 951) "VSSFIFO" "centerLeft" "R90" "roman" 10)
dbCreateLabel(cv list("AP" "pin") list(152 350) "IBOTA2" "centerLeft" "R0" "roman" 10)
dbCreateLabel(cv list("AP" "pin") list(152 290) "VREFPF0" "centerLeft" "R0" "roman" 10)
dbCreateLabel(cv list("AP" "pin") list(152 230) "IBOTA0" "centerLeft" "R0" "roman" 10)
dbCreateLabel(cv list("AP" "pin") list(152 170) "VREFNF0" "centerLeft" "R0" "roman" 10)
dbCreateLabel(cv list("AP" "pin") list(1628 410) "VREFNF2" "centerRight" "R0" "roman" 10)
dbCreateLabel(cv list("AP" "pin") list(1628 470) "VREFN2" "centerRight" "R0" "roman" 10)
dbCreateLabel(cv list("AP" "pin") list(1628 530) "VREFNF3" "centerRight" "R0" "roman" 10)
dbCreateLabel(cv list("AP" "pin") list(1628 590) "VREFN3" "centerRight" "R0" "roman" 10)
dbCreateLabel(cv list("AP" "pin") list(152 770) "VREFPF4" "centerLeft" "R0" "roman" 10)
dbCreateLabel(cv list("AP" "pin") list(152 710) "VREFNF4" "centerLeft" "R0" "roman" 10)
dbCreateLabel(cv list("AP" "pin") list(1130 788) "VIOL" "centerRight" "R90" "roman" 10)
dbCreateLabel(cv list("AP" "pin") list(1070 788) "GIOH" "centerRight" "R90" "roman" 10)
dbCreateLabel(cv list("AP" "pin") list(1010 788) "SEL<0>" "centerRight" "R90" "roman" 10)
dbCreateLabel(cv list("AP" "pin") list(950 788) "SEL<2>" "centerRight" "R90" "roman" 10)
dbCreateLabel(cv list("AP" "pin") list(890 788) "SDO" "centerRight" "R90" "roman" 10)
dbCreateLabel(cv list("AP" "pin") list(830 788) "D<0>" "centerRight" "R90" "roman" 10)
dbCreateLabel(cv list("AP" "pin") list(770 788) "D<2>" "centerRight" "R90" "roman" 10)
dbCreateLabel(cv list("AP" "pin") list(710 788) "D<4>" "centerRight" "R90" "roman" 10)
dbCreateLabel(cv list("AP" "pin") list(650 788) "RST" "centerRight" "R90" "roman" 10)
dbCreateLabel(cv list("AP" "pin") list(410 788) "VREFPF4" "centerRight" "R90" "roman" 10)
dbCreateLabel(cv list("AP" "pin") list(350 788) "VCM" "centerRight" "R90" "roman" 10)
dbCreateLabel(cv list("AP" "pin") list(290 788) "VREFNF4" "centerRight" "R90" "roman" 10)

dbSave(cv)
t
