cv = geGetWindowCellView()
pvss3ac_h_gMaster = dbOpenCellView("tphn28hpcpgv18" "PVSS3AC_H_G" "symbol")
dbCreateInst(cv pvss3ac_h_gMaster "AVSS2_left0" '(0 24.8125) "R270")
schCreateWire(cv "route" "full" '((0.000 25.000) (-0.750 25.000)) 0 0 0 nil nil)
schCreateWireLabel(cv nil '(-0.250 25.000) "AVSS2" "lowerRight" "R0" "stick" 0.0625 nil)
schCreatePin(cv nil "AVSS2" "inputOutput" nil '(-0.750 25.000) "R0")
schCreateWire(cv "route" "full" '((0.875 24.688) (1.625 24.688)) 0 0 0 nil nil)
schCreateWireLabel(cv nil '(1.125 24.688) "GIOL" "lowerLeft" "R0" "stick" 0.0625 nil)
schCreateWire(cv "route" "full" '((0.875 25.438) (1.625 25.438)) 0 0 0 nil nil)
schCreateWireLabel(cv nil '(1.125 25.438) "AVSS2_CORE" "lowerLeft" "R0" "stick" 0.0625 nil)
schCreatePin(cv nil "AVSS2_CORE" "inputOutput" nil '(1.625 25.438) "R180")
schCreateWire(cv "route" "full" '((0.875 25.062) (1.625 25.062)) 0 0 0 nil nil)
schCreateWireLabel(cv nil '(1.125 25.062) "AVDDH2" "lowerLeft" "R0" "stick" 0.0625 nil)
dbCreateInst(cv pvss3ac_h_gMaster "AVSS2_left1" '(0 22.8125) "R270")
schCreateWire(cv "route" "full" '((0.000 23.000) (-0.750 23.000)) 0 0 0 nil nil)
schCreateWireLabel(cv nil '(-0.250 23.000) "AVSS2" "lowerRight" "R0" "stick" 0.0625 nil)
schCreatePin(cv nil "AVSS2" "inputOutput" nil '(-0.750 23.000) "R0")
schCreateWire(cv "route" "full" '((0.875 22.688) (1.625 22.688)) 0 0 0 nil nil)
schCreateWireLabel(cv nil '(1.125 22.688) "GIOL" "lowerLeft" "R0" "stick" 0.0625 nil)
schCreateWire(cv "route" "full" '((0.875 23.438) (1.625 23.438)) 0 0 0 nil nil)
schCreateWireLabel(cv nil '(1.125 23.438) "AVSS2_CORE" "lowerLeft" "R0" "stick" 0.0625 nil)
schCreatePin(cv nil "AVSS2_CORE" "inputOutput" nil '(1.625 23.438) "R180")
schCreateWire(cv "route" "full" '((0.875 23.062) (1.625 23.062)) 0 0 0 nil nil)
schCreateWireLabel(cv nil '(1.125 23.062) "AVDDH2" "lowerLeft" "R0" "stick" 0.0625 nil)
pvdd3ac_h_gMaster = dbOpenCellView("tphn28hpcpgv18" "PVDD3AC_H_G" "symbol")
dbCreateInst(cv pvdd3ac_h_gMaster "AVDDH2_left2" '(0 20.8125) "R270")
schCreateWire(cv "route" "full" '((0.875 21.438) (1.625 21.438)) 0 0 0 nil nil)
schCreateWireLabel(cv nil '(1.125 21.438) "AVDDH2_CORE" "lowerLeft" "R0" "stick" 0.0625 nil)
schCreatePin(cv nil "AVDDH2_CORE" "inputOutput" nil '(1.625 21.438) "R180")
schCreateWire(cv "route" "full" '((0.875 21.062) (1.625 21.062)) 0 0 0 nil nil)
schCreateWireLabel(cv nil '(1.125 21.062) "AVSS2" "lowerLeft" "R0" "stick" 0.0625 nil)
schCreateWire(cv "route" "full" '((0.875 20.688) (1.625 20.688)) 0 0 0 nil nil)
schCreateWireLabel(cv nil '(1.125 20.688) "GIOL" "lowerLeft" "R0" "stick" 0.0625 nil)
schCreateWire(cv "route" "full" '((0.000 21.000) (-0.750 21.000)) 0 0 0 nil nil)
schCreateWireLabel(cv nil '(-0.250 21.000) "AVDDH2" "lowerRight" "R0" "stick" 0.0625 nil)
schCreatePin(cv nil "AVDDH2" "inputOutput" nil '(-0.750 21.000) "R0")
dbCreateInst(cv pvdd3ac_h_gMaster "AVDDH2_left3" '(0 18.8125) "R270")
schCreateWire(cv "route" "full" '((0.875 19.438) (1.625 19.438)) 0 0 0 nil nil)
schCreateWireLabel(cv nil '(1.125 19.438) "AVDDH2_CORE" "lowerLeft" "R0" "stick" 0.0625 nil)
schCreatePin(cv nil "AVDDH2_CORE" "inputOutput" nil '(1.625 19.438) "R180")
schCreateWire(cv "route" "full" '((0.875 19.062) (1.625 19.062)) 0 0 0 nil nil)
schCreateWireLabel(cv nil '(1.125 19.062) "AVSS2" "lowerLeft" "R0" "stick" 0.0625 nil)
schCreateWire(cv "route" "full" '((0.875 18.688) (1.625 18.688)) 0 0 0 nil nil)
schCreateWireLabel(cv nil '(1.125 18.688) "GIOL" "lowerLeft" "R0" "stick" 0.0625 nil)
schCreateWire(cv "route" "full" '((0.000 19.000) (-0.750 19.000)) 0 0 0 nil nil)
schCreateWireLabel(cv nil '(-0.250 19.000) "AVDDH2" "lowerRight" "R0" "stick" 0.0625 nil)
schCreatePin(cv nil "AVDDH2" "inputOutput" nil '(-0.750 19.000) "R0")
pvdd1ac_h_gMaster = dbOpenCellView("tphn28hpcpgv18" "PVDD1AC_H_G" "symbol")
dbCreateInst(cv pvdd1ac_h_gMaster "FVDD_left4" '(0 16.8125) "R270")
schCreateWire(cv "route" "full" '((0.875 17.062) (1.625 17.062)) 0 0 0 nil nil)
schCreateWireLabel(cv nil '(1.125 17.062) "AVSS2" "lowerLeft" "R0" "stick" 0.0625 nil)
schCreateWire(cv "route" "full" '((0.875 16.688) (1.625 16.688)) 0 0 0 nil nil)
schCreateWireLabel(cv nil '(1.125 16.688) "GIOL" "lowerLeft" "R0" "stick" 0.0625 nil)
schCreateWire(cv "route" "full" '((0.000 17.000) (-0.750 17.000)) 0 0 0 nil nil)
schCreateWireLabel(cv nil '(-0.250 17.000) "FVDD" "lowerRight" "R0" "stick" 0.0625 nil)
schCreatePin(cv nil "FVDD" "inputOutput" nil '(-0.750 17.000) "R0")
schCreateWire(cv "route" "full" '((0.875 17.438) (1.625 17.438)) 0 0 0 nil nil)
schCreateWireLabel(cv nil '(1.125 17.438) "AVDDH2" "lowerLeft" "R0" "stick" 0.0625 nil)
dbCreateInst(cv pvdd1ac_h_gMaster "FVDDH_left5" '(0 14.8125) "R270")
schCreateWire(cv "route" "full" '((0.875 15.062) (1.625 15.062)) 0 0 0 nil nil)
schCreateWireLabel(cv nil '(1.125 15.062) "AVSS2" "lowerLeft" "R0" "stick" 0.0625 nil)
schCreateWire(cv "route" "full" '((0.875 14.688) (1.625 14.688)) 0 0 0 nil nil)
schCreateWireLabel(cv nil '(1.125 14.688) "GIOL" "lowerLeft" "R0" "stick" 0.0625 nil)
schCreateWire(cv "route" "full" '((0.000 15.001) (-0.750 15.001)) 0 0 0 nil nil)
schCreateWireLabel(cv nil '(-0.250 15.001) "FVDDH" "lowerRight" "R0" "stick" 0.0625 nil)
schCreatePin(cv nil "FVDDH" "inputOutput" nil '(-0.750 15.001) "R0")
schCreateWire(cv "route" "full" '((0.875 15.438) (1.625 15.438)) 0 0 0 nil nil)
schCreateWireLabel(cv nil '(1.125 15.438) "AVDDH2" "lowerLeft" "R0" "stick" 0.0625 nil)
pvss1ac_h_gMaster = dbOpenCellView("tphn28hpcpgv18" "PVSS1AC_H_G" "symbol")
dbCreateInst(cv pvss1ac_h_gMaster "FVSS_left6" '(0 12.8125) "R270")
schCreateWire(cv "route" "full" '((0.000 13.001) (-0.750 13.001)) 0 0 0 nil nil)
schCreateWireLabel(cv nil '(-0.250 13.001) "FVSS" "lowerRight" "R0" "stick" 0.0625 nil)
schCreatePin(cv nil "FVSS" "inputOutput" nil '(-0.750 13.001) "R0")
schCreateWire(cv "route" "full" '((0.875 13.062) (1.625 13.062)) 0 0 0 nil nil)
schCreateWireLabel(cv nil '(1.125 13.062) "AVSS2" "lowerLeft" "R0" "stick" 0.0625 nil)
schCreateWire(cv "route" "full" '((0.875 12.688) (1.625 12.688)) 0 0 0 nil nil)
schCreateWireLabel(cv nil '(1.125 12.688) "GIOL" "lowerLeft" "R0" "stick" 0.0625 nil)
schCreateWire(cv "route" "full" '((0.875 13.438) (1.625 13.438)) 0 0 0 nil nil)
schCreateWireLabel(cv nil '(1.125 13.438) "AVDDH2" "lowerLeft" "R0" "stick" 0.0625 nil)
pdb3ac_h_gMaster = dbOpenCellView("tphn28hpcpgv18" "PDB3AC_H_G" "symbol")
dbCreateInst(cv pdb3ac_h_gMaster "IBOTA3_left7" '(0 10.8125) "R270")
schCreateWire(cv "route" "full" '((0.000 11.001) (-0.750 11.001)) 0 0 0 nil nil)
schCreateWireLabel(cv nil '(-0.250 11.001) "IBOTA3" "lowerRight" "R0" "stick" 0.0625 nil)
schCreatePin(cv nil "IBOTA3" "inputOutput" nil '(-0.750 11.001) "R0")
schCreateWire(cv "route" "full" '((0.875 11.062) (1.625 11.062)) 0 0 0 nil nil)
schCreateWireLabel(cv nil '(1.125 11.062) "AVSS2" "lowerLeft" "R0" "stick" 0.0625 nil)
schCreateWire(cv "route" "full" '((0.875 10.688) (1.625 10.688)) 0 0 0 nil nil)
schCreateWireLabel(cv nil '(1.125 10.688) "GIOL" "lowerLeft" "R0" "stick" 0.0625 nil)
schCreateWire(cv "route" "full" '((0.875 11.438) (1.625 11.438)) 0 0 0 nil nil)
schCreateWireLabel(cv nil '(1.125 11.438) "AVDDH2" "lowerLeft" "R0" "stick" 0.0625 nil)
dbCreateInst(cv pdb3ac_h_gMaster "IBOTA1_left8" '(0 8.8125) "R270")
schCreateWire(cv "route" "full" '((0.000 9.001) (-0.750 9.001)) 0 0 0 nil nil)
schCreateWireLabel(cv nil '(-0.250 9.001) "IBOTA1" "lowerRight" "R0" "stick" 0.0625 nil)
schCreatePin(cv nil "IBOTA1" "inputOutput" nil '(-0.750 9.001) "R0")
schCreateWire(cv "route" "full" '((0.875 9.062) (1.625 9.062)) 0 0 0 nil nil)
schCreateWireLabel(cv nil '(1.125 9.062) "AVSS2" "lowerLeft" "R0" "stick" 0.0625 nil)
schCreateWire(cv "route" "full" '((0.875 8.688) (1.625 8.688)) 0 0 0 nil nil)
schCreateWireLabel(cv nil '(1.125 8.688) "GIOL" "lowerLeft" "R0" "stick" 0.0625 nil)
schCreateWire(cv "route" "full" '((0.875 9.438) (1.625 9.438)) 0 0 0 nil nil)
schCreateWireLabel(cv nil '(1.125 9.438) "AVDDH2" "lowerLeft" "R0" "stick" 0.0625 nil)
dbCreateInst(cv pdb3ac_h_gMaster "VREFNF1_left9" '(0 6.8125) "R270")
schCreateWire(cv "route" "full" '((0.000 7.000) (-0.750 7.000)) 0 0 0 nil nil)
schCreateWireLabel(cv nil '(-0.250 7.000) "VREFNF1" "lowerRight" "R0" "stick" 0.0625 nil)
schCreatePin(cv nil "VREFNF1" "inputOutput" nil '(-0.750 7.000) "R0")
schCreateWire(cv "route" "full" '((0.875 7.062) (1.625 7.062)) 0 0 0 nil nil)
schCreateWireLabel(cv nil '(1.125 7.062) "AVSS2" "lowerLeft" "R0" "stick" 0.0625 nil)
schCreateWire(cv "route" "full" '((0.875 6.688) (1.625 6.688)) 0 0 0 nil nil)
schCreateWireLabel(cv nil '(1.125 6.688) "GIOL" "lowerLeft" "R0" "stick" 0.0625 nil)
schCreateWire(cv "route" "full" '((0.875 7.438) (1.625 7.438)) 0 0 0 nil nil)
schCreateWireLabel(cv nil '(1.125 7.438) "AVDDH2" "lowerLeft" "R0" "stick" 0.0625 nil)
dbCreateInst(cv pdb3ac_h_gMaster "VREFPF0_left10" '(0 4.8125) "R270")
schCreateWire(cv "route" "full" '((0.000 5.000) (-0.750 5.000)) 0 0 0 nil nil)
schCreateWireLabel(cv nil '(-0.250 5.000) "VREFPF0" "lowerRight" "R0" "stick" 0.0625 nil)
schCreatePin(cv nil "VREFPF0" "inputOutput" nil '(-0.750 5.000) "R0")
schCreateWire(cv "route" "full" '((0.875 5.062) (1.625 5.062)) 0 0 0 nil nil)
schCreateWireLabel(cv nil '(1.125 5.062) "AVSS2" "lowerLeft" "R0" "stick" 0.0625 nil)
schCreateWire(cv "route" "full" '((0.875 4.688) (1.625 4.688)) 0 0 0 nil nil)
schCreateWireLabel(cv nil '(1.125 4.688) "GIOL" "lowerLeft" "R0" "stick" 0.0625 nil)
schCreateWire(cv "route" "full" '((0.875 5.438) (1.625 5.438)) 0 0 0 nil nil)
schCreateWireLabel(cv nil '(1.125 5.438) "AVDDH2" "lowerLeft" "R0" "stick" 0.0625 nil)
dbCreateInst(cv pdb3ac_h_gMaster "VCM_left11" '(0 2.8125) "R270")
schCreateWire(cv "route" "full" '((0.000 3.001) (-0.750 3.001)) 0 0 0 nil nil)
schCreateWireLabel(cv nil '(-0.250 3.001) "VCM" "lowerRight" "R0" "stick" 0.0625 nil)
schCreatePin(cv nil "VCM" "inputOutput" nil '(-0.750 3.001) "R0")
schCreateWire(cv "route" "full" '((0.875 3.062) (1.625 3.062)) 0 0 0 nil nil)
schCreateWireLabel(cv nil '(1.125 3.062) "AVSS2" "lowerLeft" "R0" "stick" 0.0625 nil)
schCreateWire(cv "route" "full" '((0.875 2.688) (1.625 2.688)) 0 0 0 nil nil)
schCreateWireLabel(cv nil '(1.125 2.688) "GIOL" "lowerLeft" "R0" "stick" 0.0625 nil)
schCreateWire(cv "route" "full" '((0.875 3.438) (1.625 3.438)) 0 0 0 nil nil)
schCreateWireLabel(cv nil '(1.125 3.438) "AVDDH2" "lowerLeft" "R0" "stick" 0.0625 nil)
pvdd1ac_v_gMaster = dbOpenCellView("tphn28hpcpgv18" "PVDD1AC_V_G" "symbol")
dbCreateInst(cv pvdd1ac_v_gMaster "AVDDH1_bottom0" '(3.1875 0) "R0")
schCreateWire(cv "route" "full" '((2.938 0.875) (2.938 1.625)) 0 0 0 nil nil)
schCreateWireLabel(cv nil '(2.938 1.125) "AVSS1" "lowerLeft" "R90" "stick" 0.0625 nil)
schCreateWire(cv "route" "full" '((3.312 0.875) (3.312 1.625)) 0 0 0 nil nil)
schCreateWireLabel(cv nil '(3.312 1.125) "GIOL" "lowerLeft" "R90" "stick" 0.0625 nil)
schCreateWire(cv "route" "full" '((2.999 0.000) (2.999 -0.750)) 0 0 0 nil nil)
schCreateWireLabel(cv nil '(2.999 -0.250) "AVDDH1" "lowerRight" "R90" "stick" 0.0625 nil)
schCreatePin(cv nil "AVDDH1" "inputOutput" nil '(2.999 -0.750) "R90")
schCreateWire(cv "route" "full" '((2.562 0.875) (2.562 1.625)) 0 0 0 nil nil)
schCreateWireLabel(cv nil '(2.562 1.125) "VREFP1" "lowerLeft" "R90" "stick" 0.0625 nil)
dbCreateInst(cv pvdd1ac_v_gMaster "AVDDH1_bottom1" '(5.1875 0) "R0")
schCreateWire(cv "route" "full" '((4.938 0.875) (4.938 1.625)) 0 0 0 nil nil)
schCreateWireLabel(cv nil '(4.938 1.125) "AVSS1" "lowerLeft" "R90" "stick" 0.0625 nil)
schCreateWire(cv "route" "full" '((5.312 0.875) (5.312 1.625)) 0 0 0 nil nil)
schCreateWireLabel(cv nil '(5.312 1.125) "GIOL" "lowerLeft" "R90" "stick" 0.0625 nil)
schCreateWire(cv "route" "full" '((5.000 0.000) (5.000 -0.750)) 0 0 0 nil nil)
schCreateWireLabel(cv nil '(5.000 -0.250) "AVDDH1" "lowerRight" "R90" "stick" 0.0625 nil)
schCreatePin(cv nil "AVDDH1" "inputOutput" nil '(5.000 -0.750) "R90")
schCreateWire(cv "route" "full" '((4.562 0.875) (4.562 1.625)) 0 0 0 nil nil)
schCreateWireLabel(cv nil '(4.562 1.125) "VREFP1" "lowerLeft" "R90" "stick" 0.0625 nil)
pvss3ac_v_gMaster = dbOpenCellView("tphn28hpcpgv18" "PVSS3AC_V_G" "symbol")
dbCreateInst(cv pvss3ac_v_gMaster "AVSS1_bottom2" '(7.1875 0) "R0")
schCreateWire(cv "route" "full" '((7.000 0.000) (7.000 -0.750)) 0 0 0 nil nil)
schCreateWireLabel(cv nil '(7.000 -0.250) "AVSS1" "lowerRight" "R90" "stick" 0.0625 nil)
schCreatePin(cv nil "AVSS1" "inputOutput" nil '(7.000 -0.750) "R90")
schCreateWire(cv "route" "full" '((7.312 0.875) (7.312 1.625)) 0 0 0 nil nil)
schCreateWireLabel(cv nil '(7.312 1.125) "GIOL" "lowerLeft" "R90" "stick" 0.0625 nil)
schCreateWire(cv "route" "full" '((6.562 0.875) (6.562 1.625)) 0 0 0 nil nil)
schCreateWireLabel(cv nil '(6.562 1.125) "AVSS1_CORE" "lowerLeft" "R90" "stick" 0.0625 nil)
schCreatePin(cv nil "AVSS1_CORE" "inputOutput" nil '(6.562 1.625) "R270")
schCreateWire(cv "route" "full" '((6.938 0.875) (6.938 1.625)) 0 0 0 nil nil)
schCreateWireLabel(cv nil '(6.938 1.125) "VREFP1" "lowerLeft" "R90" "stick" 0.0625 nil)
dbCreateInst(cv pvss3ac_v_gMaster "AVSS1_bottom3" '(9.1875 0) "R0")
schCreateWire(cv "route" "full" '((8.999 0.000) (8.999 -0.750)) 0 0 0 nil nil)
schCreateWireLabel(cv nil '(8.999 -0.250) "AVSS1" "lowerRight" "R90" "stick" 0.0625 nil)
schCreatePin(cv nil "AVSS1" "inputOutput" nil '(8.999 -0.750) "R90")
schCreateWire(cv "route" "full" '((9.312 0.875) (9.312 1.625)) 0 0 0 nil nil)
schCreateWireLabel(cv nil '(9.312 1.125) "GIOL" "lowerLeft" "R90" "stick" 0.0625 nil)
schCreateWire(cv "route" "full" '((8.562 0.875) (8.562 1.625)) 0 0 0 nil nil)
schCreateWireLabel(cv nil '(8.562 1.125) "AVSS1_CORE" "lowerLeft" "R90" "stick" 0.0625 nil)
schCreatePin(cv nil "AVSS1_CORE" "inputOutput" nil '(8.562 1.625) "R270")
schCreateWire(cv "route" "full" '((8.938 0.875) (8.938 1.625)) 0 0 0 nil nil)
schCreateWireLabel(cv nil '(8.938 1.125) "VREFP1" "lowerLeft" "R90" "stick" 0.0625 nil)
pvdd3ac_v_gMaster = dbOpenCellView("tphn28hpcpgv18" "PVDD3AC_V_G" "symbol")
dbCreateInst(cv pvdd3ac_v_gMaster "VREFP1_bottom4" '(11.1875 0) "R0")
schCreateWire(cv "route" "full" '((10.562 0.875) (10.562 1.625)) 0 0 0 nil nil)
schCreateWireLabel(cv nil '(10.562 1.125) "VREFP1_CORE" "lowerLeft" "R90" "stick" 0.0625 nil)
schCreatePin(cv nil "VREFP1_CORE" "inputOutput" nil '(10.562 1.625) "R270")
schCreateWire(cv "route" "full" '((10.938 0.875) (10.938 1.625)) 0 0 0 nil nil)
schCreateWireLabel(cv nil '(10.938 1.125) "AVSS1" "lowerLeft" "R90" "stick" 0.0625 nil)
schCreateWire(cv "route" "full" '((11.312 0.875) (11.312 1.625)) 0 0 0 nil nil)
schCreateWireLabel(cv nil '(11.312 1.125) "GIOL" "lowerLeft" "R90" "stick" 0.0625 nil)
schCreateWire(cv "route" "full" '((10.999 0.000) (10.999 -0.750)) 0 0 0 nil nil)
schCreateWireLabel(cv nil '(10.999 -0.250) "VREFP1" "lowerRight" "R90" "stick" 0.0625 nil)
schCreatePin(cv nil "VREFP1" "inputOutput" nil '(10.999 -0.750) "R90")
pdb3ac_v_gMaster = dbOpenCellView("tphn28hpcpgv18" "PDB3AC_V_G" "symbol")
dbCreateInst(cv pdb3ac_v_gMaster "VREFN1_bottom5" '(13.1875 0) "R0")
schCreateWire(cv "route" "full" '((12.999 0.000) (12.999 -0.750)) 0 0 0 nil nil)
schCreateWireLabel(cv nil '(12.999 -0.250) "VREFN1" "lowerRight" "R90" "stick" 0.0625 nil)
schCreatePin(cv nil "VREFN1" "inputOutput" nil '(12.999 -0.750) "R90")
schCreateWire(cv "route" "full" '((12.938 0.875) (12.938 1.625)) 0 0 0 nil nil)
schCreateWireLabel(cv nil '(12.938 1.125) "AVSS1" "lowerLeft" "R90" "stick" 0.0625 nil)
schCreateWire(cv "route" "full" '((13.312 0.875) (13.312 1.625)) 0 0 0 nil nil)
schCreateWireLabel(cv nil '(13.312 1.125) "GIOL" "lowerLeft" "R90" "stick" 0.0625 nil)
schCreateWire(cv "route" "full" '((12.562 0.875) (12.562 1.625)) 0 0 0 nil nil)
schCreateWireLabel(cv nil '(12.562 1.125) "VREFP1" "lowerLeft" "R90" "stick" 0.0625 nil)
dbCreateInst(cv pvdd3ac_v_gMaster "AVDDH0_bottom6" '(15.1875 0) "R0")
schCreateWire(cv "route" "full" '((14.562 0.875) (14.562 1.625)) 0 0 0 nil nil)
schCreateWireLabel(cv nil '(14.562 1.125) "AVDDH0_CORE" "lowerLeft" "R90" "stick" 0.0625 nil)
schCreatePin(cv nil "AVDDH0_CORE" "inputOutput" nil '(14.562 1.625) "R270")
schCreateWire(cv "route" "full" '((14.938 0.875) (14.938 1.625)) 0 0 0 nil nil)
schCreateWireLabel(cv nil '(14.938 1.125) "AVSS0" "lowerLeft" "R90" "stick" 0.0625 nil)
schCreateWire(cv "route" "full" '((15.312 0.875) (15.312 1.625)) 0 0 0 nil nil)
schCreateWireLabel(cv nil '(15.312 1.125) "GIOL" "lowerLeft" "R90" "stick" 0.0625 nil)
schCreateWire(cv "route" "full" '((14.999 0.000) (14.999 -0.750)) 0 0 0 nil nil)
schCreateWireLabel(cv nil '(14.999 -0.250) "AVDDH0" "lowerRight" "R90" "stick" 0.0625 nil)
schCreatePin(cv nil "AVDDH0" "inputOutput" nil '(14.999 -0.750) "R90")
dbCreateInst(cv pvdd3ac_v_gMaster "AVDDH0_bottom7" '(17.1875 0) "R0")
schCreateWire(cv "route" "full" '((16.562 0.875) (16.562 1.625)) 0 0 0 nil nil)
schCreateWireLabel(cv nil '(16.562 1.125) "AVDDH0_CORE" "lowerLeft" "R90" "stick" 0.0625 nil)
schCreatePin(cv nil "AVDDH0_CORE" "inputOutput" nil '(16.562 1.625) "R270")
schCreateWire(cv "route" "full" '((16.938 0.875) (16.938 1.625)) 0 0 0 nil nil)
schCreateWireLabel(cv nil '(16.938 1.125) "AVSS0" "lowerLeft" "R90" "stick" 0.0625 nil)
schCreateWire(cv "route" "full" '((17.312 0.875) (17.312 1.625)) 0 0 0 nil nil)
schCreateWireLabel(cv nil '(17.312 1.125) "GIOL" "lowerLeft" "R90" "stick" 0.0625 nil)
schCreateWire(cv "route" "full" '((17.000 0.000) (17.000 -0.750)) 0 0 0 nil nil)
schCreateWireLabel(cv nil '(17.000 -0.250) "AVDDH0" "lowerRight" "R90" "stick" 0.0625 nil)
schCreatePin(cv nil "AVDDH0" "inputOutput" nil '(17.000 -0.750) "R90")
dbCreateInst(cv pvss3ac_v_gMaster "AVSS0_bottom8" '(19.1875 0) "R0")
schCreateWire(cv "route" "full" '((19.000 0.000) (19.000 -0.750)) 0 0 0 nil nil)
schCreateWireLabel(cv nil '(19.000 -0.250) "AVSS0" "lowerRight" "R90" "stick" 0.0625 nil)
schCreatePin(cv nil "AVSS0" "inputOutput" nil '(19.000 -0.750) "R90")
schCreateWire(cv "route" "full" '((19.312 0.875) (19.312 1.625)) 0 0 0 nil nil)
schCreateWireLabel(cv nil '(19.312 1.125) "GIOL" "lowerLeft" "R90" "stick" 0.0625 nil)
schCreateWire(cv "route" "full" '((18.562 0.875) (18.562 1.625)) 0 0 0 nil nil)
schCreateWireLabel(cv nil '(18.562 1.125) "AVSS0_CORE" "lowerLeft" "R90" "stick" 0.0625 nil)
schCreatePin(cv nil "AVSS0_CORE" "inputOutput" nil '(18.562 1.625) "R270")
schCreateWire(cv "route" "full" '((18.938 0.875) (18.938 1.625)) 0 0 0 nil nil)
schCreateWireLabel(cv nil '(18.938 1.125) "AVDDH0" "lowerLeft" "R90" "stick" 0.0625 nil)
dbCreateInst(cv pvss3ac_v_gMaster "AVSS0_bottom9" '(21.1875 0) "R0")
schCreateWire(cv "route" "full" '((21.000 0.000) (21.000 -0.750)) 0 0 0 nil nil)
schCreateWireLabel(cv nil '(21.000 -0.250) "AVSS0" "lowerRight" "R90" "stick" 0.0625 nil)
schCreatePin(cv nil "AVSS0" "inputOutput" nil '(21.000 -0.750) "R90")
schCreateWire(cv "route" "full" '((21.312 0.875) (21.312 1.625)) 0 0 0 nil nil)
schCreateWireLabel(cv nil '(21.312 1.125) "GIOL" "lowerLeft" "R90" "stick" 0.0625 nil)
schCreateWire(cv "route" "full" '((20.562 0.875) (20.562 1.625)) 0 0 0 nil nil)
schCreateWireLabel(cv nil '(20.562 1.125) "AVSS0_CORE" "lowerLeft" "R90" "stick" 0.0625 nil)
schCreatePin(cv nil "AVSS0_CORE" "inputOutput" nil '(20.562 1.625) "R270")
schCreateWire(cv "route" "full" '((20.938 0.875) (20.938 1.625)) 0 0 0 nil nil)
schCreateWireLabel(cv nil '(20.938 1.125) "AVDDH0" "lowerLeft" "R90" "stick" 0.0625 nil)
dbCreateInst(cv pdb3ac_v_gMaster "VREFP0_bottom10" '(23.1875 0) "R0")
schCreateWire(cv "route" "full" '((23.000 0.000) (23.000 -0.750)) 0 0 0 nil nil)
schCreateWireLabel(cv nil '(23.000 -0.250) "VREFP0" "lowerRight" "R90" "stick" 0.0625 nil)
schCreatePin(cv nil "VREFP0" "inputOutput" nil '(23.000 -0.750) "R90")
schCreateWire(cv "route" "full" '((22.938 0.875) (22.938 1.625)) 0 0 0 nil nil)
schCreateWireLabel(cv nil '(22.938 1.125) "AVSS0" "lowerLeft" "R90" "stick" 0.0625 nil)
schCreateWire(cv "route" "full" '((23.312 0.875) (23.312 1.625)) 0 0 0 nil nil)
schCreateWireLabel(cv nil '(23.312 1.125) "GIOL" "lowerLeft" "R90" "stick" 0.0625 nil)
schCreateWire(cv "route" "full" '((22.562 0.875) (22.562 1.625)) 0 0 0 nil nil)
schCreateWireLabel(cv nil '(22.562 1.125) "AVDDH0" "lowerLeft" "R90" "stick" 0.0625 nil)
dbCreateInst(cv pdb3ac_v_gMaster "VREFN0_bottom11" '(25.1875 0) "R0")
schCreateWire(cv "route" "full" '((25.000 0.000) (25.000 -0.750)) 0 0 0 nil nil)
schCreateWireLabel(cv nil '(25.000 -0.250) "VREFN0" "lowerRight" "R90" "stick" 0.0625 nil)
schCreatePin(cv nil "VREFN0" "inputOutput" nil '(25.000 -0.750) "R90")
schCreateWire(cv "route" "full" '((24.938 0.875) (24.938 1.625)) 0 0 0 nil nil)
schCreateWireLabel(cv nil '(24.938 1.125) "AVSS0" "lowerLeft" "R90" "stick" 0.0625 nil)
schCreateWire(cv "route" "full" '((25.312 0.875) (25.312 1.625)) 0 0 0 nil nil)
schCreateWireLabel(cv nil '(25.312 1.125) "GIOL" "lowerLeft" "R90" "stick" 0.0625 nil)
schCreateWire(cv "route" "full" '((24.562 0.875) (24.562 1.625)) 0 0 0 nil nil)
schCreateWireLabel(cv nil '(24.562 1.125) "AVDDH0" "lowerLeft" "R90" "stick" 0.0625 nil)
dbCreateInst(cv pdb3ac_v_gMaster "VINP_bottom12" '(27.1875 0) "R0")
schCreateWire(cv "route" "full" '((27.000 0.000) (27.000 -0.750)) 0 0 0 nil nil)
schCreateWireLabel(cv nil '(27.000 -0.250) "VINP" "lowerRight" "R90" "stick" 0.0625 nil)
schCreatePin(cv nil "VINP" "inputOutput" nil '(27.000 -0.750) "R90")
schCreateWire(cv "route" "full" '((26.938 0.875) (26.938 1.625)) 0 0 0 nil nil)
schCreateWireLabel(cv nil '(26.938 1.125) "AVSS0" "lowerLeft" "R90" "stick" 0.0625 nil)
schCreateWire(cv "route" "full" '((27.312 0.875) (27.312 1.625)) 0 0 0 nil nil)
schCreateWireLabel(cv nil '(27.312 1.125) "GIOL" "lowerLeft" "R90" "stick" 0.0625 nil)
schCreateWire(cv "route" "full" '((26.562 0.875) (26.562 1.625)) 0 0 0 nil nil)
schCreateWireLabel(cv nil '(26.562 1.125) "AVDDH0" "lowerLeft" "R90" "stick" 0.0625 nil)
dbCreateInst(cv pdb3ac_v_gMaster "VINN_bottom13" '(29.1875 0) "R0")
schCreateWire(cv "route" "full" '((29.000 0.000) (29.000 -0.750)) 0 0 0 nil nil)
schCreateWireLabel(cv nil '(29.000 -0.250) "VINN" "lowerRight" "R90" "stick" 0.0625 nil)
schCreatePin(cv nil "VINN" "inputOutput" nil '(29.000 -0.750) "R90")
schCreateWire(cv "route" "full" '((28.938 0.875) (28.938 1.625)) 0 0 0 nil nil)
schCreateWireLabel(cv nil '(28.938 1.125) "AVSS0" "lowerLeft" "R90" "stick" 0.0625 nil)
schCreateWire(cv "route" "full" '((29.312 0.875) (29.312 1.625)) 0 0 0 nil nil)
schCreateWireLabel(cv nil '(29.312 1.125) "GIOL" "lowerLeft" "R90" "stick" 0.0625 nil)
schCreateWire(cv "route" "full" '((28.562 0.875) (28.562 1.625)) 0 0 0 nil nil)
schCreateWireLabel(cv nil '(28.562 1.125) "AVDDH0" "lowerLeft" "R90" "stick" 0.0625 nil)
dbCreateInst(cv pdb3ac_v_gMaster "VREFN0_bottom14" '(31.1875 0) "R0")
schCreateWire(cv "route" "full" '((31.000 0.000) (31.000 -0.750)) 0 0 0 nil nil)
schCreateWireLabel(cv nil '(31.000 -0.250) "VREFN0" "lowerRight" "R90" "stick" 0.0625 nil)
schCreatePin(cv nil "VREFN0" "inputOutput" nil '(31.000 -0.750) "R90")
schCreateWire(cv "route" "full" '((30.938 0.875) (30.938 1.625)) 0 0 0 nil nil)
schCreateWireLabel(cv nil '(30.938 1.125) "AVSS0" "lowerLeft" "R90" "stick" 0.0625 nil)
schCreateWire(cv "route" "full" '((31.312 0.875) (31.312 1.625)) 0 0 0 nil nil)
schCreateWireLabel(cv nil '(31.312 1.125) "GIOL" "lowerLeft" "R90" "stick" 0.0625 nil)
schCreateWire(cv "route" "full" '((30.562 0.875) (30.562 1.625)) 0 0 0 nil nil)
schCreateWireLabel(cv nil '(30.562 1.125) "AVDDH0" "lowerLeft" "R90" "stick" 0.0625 nil)
dbCreateInst(cv pdb3ac_v_gMaster "VREFP0_bottom15" '(33.1875 0) "R0")
schCreateWire(cv "route" "full" '((32.999 0.000) (32.999 -0.750)) 0 0 0 nil nil)
schCreateWireLabel(cv nil '(32.999 -0.250) "VREFP0" "lowerRight" "R90" "stick" 0.0625 nil)
schCreatePin(cv nil "VREFP0" "inputOutput" nil '(32.999 -0.750) "R90")
schCreateWire(cv "route" "full" '((32.938 0.875) (32.938 1.625)) 0 0 0 nil nil)
schCreateWireLabel(cv nil '(32.938 1.125) "AVSS0" "lowerLeft" "R90" "stick" 0.0625 nil)
schCreateWire(cv "route" "full" '((33.312 0.875) (33.312 1.625)) 0 0 0 nil nil)
schCreateWireLabel(cv nil '(33.312 1.125) "GIOL" "lowerLeft" "R90" "stick" 0.0625 nil)
schCreateWire(cv "route" "full" '((32.562 0.875) (32.562 1.625)) 0 0 0 nil nil)
schCreateWireLabel(cv nil '(32.562 1.125) "AVDDH0" "lowerLeft" "R90" "stick" 0.0625 nil)
dbCreateInst(cv pvss3ac_v_gMaster "AVSS0_bottom16" '(35.1875 0) "R0")
schCreateWire(cv "route" "full" '((34.999 0.000) (34.999 -0.750)) 0 0 0 nil nil)
schCreateWireLabel(cv nil '(34.999 -0.250) "AVSS0" "lowerRight" "R90" "stick" 0.0625 nil)
schCreatePin(cv nil "AVSS0" "inputOutput" nil '(34.999 -0.750) "R90")
schCreateWire(cv "route" "full" '((35.312 0.875) (35.312 1.625)) 0 0 0 nil nil)
schCreateWireLabel(cv nil '(35.312 1.125) "GIOL" "lowerLeft" "R90" "stick" 0.0625 nil)
schCreateWire(cv "route" "full" '((34.562 0.875) (34.562 1.625)) 0 0 0 nil nil)
schCreateWireLabel(cv nil '(34.562 1.125) "AVSS0_CORE" "lowerLeft" "R90" "stick" 0.0625 nil)
schCreatePin(cv nil "AVSS0_CORE" "inputOutput" nil '(34.562 1.625) "R270")
schCreateWire(cv "route" "full" '((34.938 0.875) (34.938 1.625)) 0 0 0 nil nil)
schCreateWireLabel(cv nil '(34.938 1.125) "AVDDH0" "lowerLeft" "R90" "stick" 0.0625 nil)
dbCreateInst(cv pvss3ac_v_gMaster "AVSS0_bottom17" '(37.1875 0) "R0")
schCreateWire(cv "route" "full" '((36.999 0.000) (36.999 -0.750)) 0 0 0 nil nil)
schCreateWireLabel(cv nil '(36.999 -0.250) "AVSS0" "lowerRight" "R90" "stick" 0.0625 nil)
schCreatePin(cv nil "AVSS0" "inputOutput" nil '(36.999 -0.750) "R90")
schCreateWire(cv "route" "full" '((37.312 0.875) (37.312 1.625)) 0 0 0 nil nil)
schCreateWireLabel(cv nil '(37.312 1.125) "GIOL" "lowerLeft" "R90" "stick" 0.0625 nil)
schCreateWire(cv "route" "full" '((36.562 0.875) (36.562 1.625)) 0 0 0 nil nil)
schCreateWireLabel(cv nil '(36.562 1.125) "AVSS0_CORE" "lowerLeft" "R90" "stick" 0.0625 nil)
schCreatePin(cv nil "AVSS0_CORE" "inputOutput" nil '(36.562 1.625) "R270")
schCreateWire(cv "route" "full" '((36.938 0.875) (36.938 1.625)) 0 0 0 nil nil)
schCreateWireLabel(cv nil '(36.938 1.125) "AVDDH0" "lowerLeft" "R90" "stick" 0.0625 nil)
dbCreateInst(cv pvdd3ac_v_gMaster "AVDDH0_bottom18" '(39.1875 0) "R0")
schCreateWire(cv "route" "full" '((38.562 0.875) (38.562 1.625)) 0 0 0 nil nil)
schCreateWireLabel(cv nil '(38.562 1.125) "AVDDH0_CORE" "lowerLeft" "R90" "stick" 0.0625 nil)
schCreatePin(cv nil "AVDDH0_CORE" "inputOutput" nil '(38.562 1.625) "R270")
schCreateWire(cv "route" "full" '((38.938 0.875) (38.938 1.625)) 0 0 0 nil nil)
schCreateWireLabel(cv nil '(38.938 1.125) "AVSS0" "lowerLeft" "R90" "stick" 0.0625 nil)
schCreateWire(cv "route" "full" '((39.312 0.875) (39.312 1.625)) 0 0 0 nil nil)
schCreateWireLabel(cv nil '(39.312 1.125) "GIOL" "lowerLeft" "R90" "stick" 0.0625 nil)
schCreateWire(cv "route" "full" '((38.999 0.000) (38.999 -0.750)) 0 0 0 nil nil)
schCreateWireLabel(cv nil '(38.999 -0.250) "AVDDH0" "lowerRight" "R90" "stick" 0.0625 nil)
schCreatePin(cv nil "AVDDH0" "inputOutput" nil '(38.999 -0.750) "R90")
dbCreateInst(cv pvdd3ac_v_gMaster "AVDDH0_bottom19" '(41.1875 0) "R0")
schCreateWire(cv "route" "full" '((40.562 0.875) (40.562 1.625)) 0 0 0 nil nil)
schCreateWireLabel(cv nil '(40.562 1.125) "AVDDH0_CORE" "lowerLeft" "R90" "stick" 0.0625 nil)
schCreatePin(cv nil "AVDDH0_CORE" "inputOutput" nil '(40.562 1.625) "R270")
schCreateWire(cv "route" "full" '((40.938 0.875) (40.938 1.625)) 0 0 0 nil nil)
schCreateWireLabel(cv nil '(40.938 1.125) "AVSS0" "lowerLeft" "R90" "stick" 0.0625 nil)
schCreateWire(cv "route" "full" '((41.312 0.875) (41.312 1.625)) 0 0 0 nil nil)
schCreateWireLabel(cv nil '(41.312 1.125) "GIOL" "lowerLeft" "R90" "stick" 0.0625 nil)
schCreateWire(cv "route" "full" '((40.999 0.000) (40.999 -0.750)) 0 0 0 nil nil)
schCreateWireLabel(cv nil '(40.999 -0.250) "AVDDH0" "lowerRight" "R90" "stick" 0.0625 nil)
schCreatePin(cv nil "AVDDH0" "inputOutput" nil '(40.999 -0.750) "R90")
dbCreateInst(cv pdb3ac_v_gMaster "VREFN1_bottom20" '(43.1875 0) "R0")
schCreateWire(cv "route" "full" '((42.999 0.000) (42.999 -0.750)) 0 0 0 nil nil)
schCreateWireLabel(cv nil '(42.999 -0.250) "VREFN1" "lowerRight" "R90" "stick" 0.0625 nil)
schCreatePin(cv nil "VREFN1" "inputOutput" nil '(42.999 -0.750) "R90")
schCreateWire(cv "route" "full" '((42.938 0.875) (42.938 1.625)) 0 0 0 nil nil)
schCreateWireLabel(cv nil '(42.938 1.125) "AVSS1" "lowerLeft" "R90" "stick" 0.0625 nil)
schCreateWire(cv "route" "full" '((43.312 0.875) (43.312 1.625)) 0 0 0 nil nil)
schCreateWireLabel(cv nil '(43.312 1.125) "GIOL" "lowerLeft" "R90" "stick" 0.0625 nil)
schCreateWire(cv "route" "full" '((42.562 0.875) (42.562 1.625)) 0 0 0 nil nil)
schCreateWireLabel(cv nil '(42.562 1.125) "VREFP1" "lowerLeft" "R90" "stick" 0.0625 nil)
dbCreateInst(cv pvdd3ac_v_gMaster "VREFP1_bottom21" '(45.1875 0) "R0")
schCreateWire(cv "route" "full" '((44.562 0.875) (44.562 1.625)) 0 0 0 nil nil)
schCreateWireLabel(cv nil '(44.562 1.125) "VREFP1_CORE" "lowerLeft" "R90" "stick" 0.0625 nil)
schCreatePin(cv nil "VREFP1_CORE" "inputOutput" nil '(44.562 1.625) "R270")
schCreateWire(cv "route" "full" '((44.938 0.875) (44.938 1.625)) 0 0 0 nil nil)
schCreateWireLabel(cv nil '(44.938 1.125) "AVSS1" "lowerLeft" "R90" "stick" 0.0625 nil)
schCreateWire(cv "route" "full" '((45.312 0.875) (45.312 1.625)) 0 0 0 nil nil)
schCreateWireLabel(cv nil '(45.312 1.125) "GIOL" "lowerLeft" "R90" "stick" 0.0625 nil)
schCreateWire(cv "route" "full" '((44.999 0.000) (44.999 -0.750)) 0 0 0 nil nil)
schCreateWireLabel(cv nil '(44.999 -0.250) "VREFP1" "lowerRight" "R90" "stick" 0.0625 nil)
schCreatePin(cv nil "VREFP1" "inputOutput" nil '(44.999 -0.750) "R90")
dbCreateInst(cv pvss3ac_v_gMaster "AVSS1_bottom22" '(47.1875 0) "R0")
schCreateWire(cv "route" "full" '((46.999 0.000) (46.999 -0.750)) 0 0 0 nil nil)
schCreateWireLabel(cv nil '(46.999 -0.250) "AVSS1" "lowerRight" "R90" "stick" 0.0625 nil)
schCreatePin(cv nil "AVSS1" "inputOutput" nil '(46.999 -0.750) "R90")
schCreateWire(cv "route" "full" '((47.312 0.875) (47.312 1.625)) 0 0 0 nil nil)
schCreateWireLabel(cv nil '(47.312 1.125) "GIOL" "lowerLeft" "R90" "stick" 0.0625 nil)
schCreateWire(cv "route" "full" '((46.562 0.875) (46.562 1.625)) 0 0 0 nil nil)
schCreateWireLabel(cv nil '(46.562 1.125) "AVSS1_CORE" "lowerLeft" "R90" "stick" 0.0625 nil)
schCreatePin(cv nil "AVSS1_CORE" "inputOutput" nil '(46.562 1.625) "R270")
schCreateWire(cv "route" "full" '((46.938 0.875) (46.938 1.625)) 0 0 0 nil nil)
schCreateWireLabel(cv nil '(46.938 1.125) "VREFP1" "lowerLeft" "R90" "stick" 0.0625 nil)
dbCreateInst(cv pvss3ac_v_gMaster "AVSS1_bottom23" '(49.1875 0) "R0")
schCreateWire(cv "route" "full" '((48.999 0.000) (48.999 -0.750)) 0 0 0 nil nil)
schCreateWireLabel(cv nil '(48.999 -0.250) "AVSS1" "lowerRight" "R90" "stick" 0.0625 nil)
schCreatePin(cv nil "AVSS1" "inputOutput" nil '(48.999 -0.750) "R90")
schCreateWire(cv "route" "full" '((49.312 0.875) (49.312 1.625)) 0 0 0 nil nil)
schCreateWireLabel(cv nil '(49.312 1.125) "GIOL" "lowerLeft" "R90" "stick" 0.0625 nil)
schCreateWire(cv "route" "full" '((48.562 0.875) (48.562 1.625)) 0 0 0 nil nil)
schCreateWireLabel(cv nil '(48.562 1.125) "AVSS1_CORE" "lowerLeft" "R90" "stick" 0.0625 nil)
schCreatePin(cv nil "AVSS1_CORE" "inputOutput" nil '(48.562 1.625) "R270")
schCreateWire(cv "route" "full" '((48.938 0.875) (48.938 1.625)) 0 0 0 nil nil)
schCreateWireLabel(cv nil '(48.938 1.125) "VREFP1" "lowerLeft" "R90" "stick" 0.0625 nil)
dbCreateInst(cv pvdd1ac_v_gMaster "AVDDH1_bottom24" '(51.1875 0) "R0")
schCreateWire(cv "route" "full" '((50.938 0.875) (50.938 1.625)) 0 0 0 nil nil)
schCreateWireLabel(cv nil '(50.938 1.125) "AVSS1" "lowerLeft" "R90" "stick" 0.0625 nil)
schCreateWire(cv "route" "full" '((51.312 0.875) (51.312 1.625)) 0 0 0 nil nil)
schCreateWireLabel(cv nil '(51.312 1.125) "GIOL" "lowerLeft" "R90" "stick" 0.0625 nil)
schCreateWire(cv "route" "full" '((50.999 0.000) (50.999 -0.750)) 0 0 0 nil nil)
schCreateWireLabel(cv nil '(50.999 -0.250) "AVDDH1" "lowerRight" "R90" "stick" 0.0625 nil)
schCreatePin(cv nil "AVDDH1" "inputOutput" nil '(50.999 -0.750) "R90")
schCreateWire(cv "route" "full" '((50.562 0.875) (50.562 1.625)) 0 0 0 nil nil)
schCreateWireLabel(cv nil '(50.562 1.125) "VREFP1" "lowerLeft" "R90" "stick" 0.0625 nil)
dbCreateInst(cv pvdd1ac_v_gMaster "AVDDH1_bottom25" '(53.1875 0) "R0")
schCreateWire(cv "route" "full" '((52.938 0.875) (52.938 1.625)) 0 0 0 nil nil)
schCreateWireLabel(cv nil '(52.938 1.125) "AVSS1" "lowerLeft" "R90" "stick" 0.0625 nil)
schCreateWire(cv "route" "full" '((53.312 0.875) (53.312 1.625)) 0 0 0 nil nil)
schCreateWireLabel(cv nil '(53.312 1.125) "GIOL" "lowerLeft" "R90" "stick" 0.0625 nil)
schCreateWire(cv "route" "full" '((52.999 0.000) (52.999 -0.750)) 0 0 0 nil nil)
schCreateWireLabel(cv nil '(52.999 -0.250) "AVDDH1" "lowerRight" "R90" "stick" 0.0625 nil)
schCreatePin(cv nil "AVDDH1" "inputOutput" nil '(52.999 -0.750) "R90")
schCreateWire(cv "route" "full" '((52.562 0.875) (52.562 1.625)) 0 0 0 nil nil)
schCreateWireLabel(cv nil '(52.562 1.125) "VREFP1" "lowerLeft" "R90" "stick" 0.0625 nil)
dbCreateInst(cv pvss1ac_h_gMaster "CVSS_right0" '(56.0 3.1875) "R90")
schCreateWire(cv "route" "full" '((56.000 2.999) (56.750 2.999)) 0 0 0 nil nil)
schCreateWireLabel(cv nil '(56.250 2.999) "CVSS" "lowerLeft" "R0" "stick" 0.0625 nil)
schCreatePin(cv nil "CVSS" "inputOutput" nil '(56.750 2.999) "R180")
schCreateWire(cv "route" "full" '((55.125 2.938) (54.375 2.938)) 0 0 0 nil nil)
schCreateWireLabel(cv nil '(54.875 2.938) "AVSS3" "lowerRight" "R0" "stick" 0.0625 nil)
schCreateWire(cv "route" "full" '((55.125 3.312) (54.375 3.312)) 0 0 0 nil nil)
schCreateWireLabel(cv nil '(54.875 3.312) "GIOL" "lowerRight" "R0" "stick" 0.0625 nil)
schCreateWire(cv "route" "full" '((55.125 2.562) (54.375 2.562)) 0 0 0 nil nil)
schCreateWireLabel(cv nil '(54.875 2.562) "AVDDH3" "lowerRight" "R0" "stick" 0.0625 nil)
dbCreateInst(cv pdb3ac_h_gMaster "CLKN_right1" '(56.0 5.1875) "R90")
schCreateWire(cv "route" "full" '((56.000 5.000) (56.750 5.000)) 0 0 0 nil nil)
schCreateWireLabel(cv nil '(56.250 5.000) "CLKN" "lowerLeft" "R0" "stick" 0.0625 nil)
schCreatePin(cv nil "CLKN" "inputOutput" nil '(56.750 5.000) "R180")
schCreateWire(cv "route" "full" '((55.125 4.938) (54.375 4.938)) 0 0 0 nil nil)
schCreateWireLabel(cv nil '(54.875 4.938) "AVSS3" "lowerRight" "R0" "stick" 0.0625 nil)
schCreateWire(cv "route" "full" '((55.125 5.312) (54.375 5.312)) 0 0 0 nil nil)
schCreateWireLabel(cv nil '(54.875 5.312) "GIOL" "lowerRight" "R0" "stick" 0.0625 nil)
schCreateWire(cv "route" "full" '((55.125 4.562) (54.375 4.562)) 0 0 0 nil nil)
schCreateWireLabel(cv nil '(54.875 4.562) "AVDDH3" "lowerRight" "R0" "stick" 0.0625 nil)
dbCreateInst(cv pdb3ac_h_gMaster "CLKP_right2" '(56.0 7.1875) "R90")
schCreateWire(cv "route" "full" '((56.000 7.000) (56.750 7.000)) 0 0 0 nil nil)
schCreateWireLabel(cv nil '(56.250 7.000) "CLKP" "lowerLeft" "R0" "stick" 0.0625 nil)
schCreatePin(cv nil "CLKP" "inputOutput" nil '(56.750 7.000) "R180")
schCreateWire(cv "route" "full" '((55.125 6.938) (54.375 6.938)) 0 0 0 nil nil)
schCreateWireLabel(cv nil '(54.875 6.938) "AVSS3" "lowerRight" "R0" "stick" 0.0625 nil)
schCreateWire(cv "route" "full" '((55.125 7.312) (54.375 7.312)) 0 0 0 nil nil)
schCreateWireLabel(cv nil '(54.875 7.312) "GIOL" "lowerRight" "R0" "stick" 0.0625 nil)
schCreateWire(cv "route" "full" '((55.125 6.562) (54.375 6.562)) 0 0 0 nil nil)
schCreateWireLabel(cv nil '(54.875 6.562) "AVDDH3" "lowerRight" "R0" "stick" 0.0625 nil)
dbCreateInst(cv pvdd1ac_h_gMaster "CVDD_right3" '(56.0 9.1875) "R90")
schCreateWire(cv "route" "full" '((55.125 8.938) (54.375 8.938)) 0 0 0 nil nil)
schCreateWireLabel(cv nil '(54.875 8.938) "AVSS3" "lowerRight" "R0" "stick" 0.0625 nil)
schCreateWire(cv "route" "full" '((55.125 9.312) (54.375 9.312)) 0 0 0 nil nil)
schCreateWireLabel(cv nil '(54.875 9.312) "GIOL" "lowerRight" "R0" "stick" 0.0625 nil)
schCreateWire(cv "route" "full" '((56.000 8.999) (56.750 8.999)) 0 0 0 nil nil)
schCreateWireLabel(cv nil '(56.250 8.999) "CVDD" "lowerLeft" "R0" "stick" 0.0625 nil)
schCreatePin(cv nil "CVDD" "inputOutput" nil '(56.750 8.999) "R180")
schCreateWire(cv "route" "full" '((55.125 8.562) (54.375 8.562)) 0 0 0 nil nil)
schCreateWireLabel(cv nil '(54.875 8.562) "AVDDH3" "lowerRight" "R0" "stick" 0.0625 nil)
dbCreateInst(cv pdb3ac_h_gMaster "IBF_right4" '(56.0 11.1875) "R90")
schCreateWire(cv "route" "full" '((56.000 10.999) (56.750 10.999)) 0 0 0 nil nil)
schCreateWireLabel(cv nil '(56.250 10.999) "IBF" "lowerLeft" "R0" "stick" 0.0625 nil)
schCreatePin(cv nil "IBF" "inputOutput" nil '(56.750 10.999) "R180")
schCreateWire(cv "route" "full" '((55.125 10.938) (54.375 10.938)) 0 0 0 nil nil)
schCreateWireLabel(cv nil '(54.875 10.938) "AVSS3" "lowerRight" "R0" "stick" 0.0625 nil)
schCreateWire(cv "route" "full" '((55.125 11.312) (54.375 11.312)) 0 0 0 nil nil)
schCreateWireLabel(cv nil '(54.875 11.312) "GIOL" "lowerRight" "R0" "stick" 0.0625 nil)
schCreateWire(cv "route" "full" '((55.125 10.562) (54.375 10.562)) 0 0 0 nil nil)
schCreateWireLabel(cv nil '(54.875 10.562) "AVDDH3" "lowerRight" "R0" "stick" 0.0625 nil)
dbCreateInst(cv pdb3ac_h_gMaster "VREFPF2_right5" '(56.0 13.1875) "R90")
schCreateWire(cv "route" "full" '((56.000 12.999) (56.750 12.999)) 0 0 0 nil nil)
schCreateWireLabel(cv nil '(56.250 12.999) "VREFPF2" "lowerLeft" "R0" "stick" 0.0625 nil)
schCreatePin(cv nil "VREFPF2" "inputOutput" nil '(56.750 12.999) "R180")
schCreateWire(cv "route" "full" '((55.125 12.938) (54.375 12.938)) 0 0 0 nil nil)
schCreateWireLabel(cv nil '(54.875 12.938) "AVSS3" "lowerRight" "R0" "stick" 0.0625 nil)
schCreateWire(cv "route" "full" '((55.125 13.312) (54.375 13.312)) 0 0 0 nil nil)
schCreateWireLabel(cv nil '(54.875 13.312) "GIOL" "lowerRight" "R0" "stick" 0.0625 nil)
schCreateWire(cv "route" "full" '((55.125 12.562) (54.375 12.562)) 0 0 0 nil nil)
schCreateWireLabel(cv nil '(54.875 12.562) "AVDDH3" "lowerRight" "R0" "stick" 0.0625 nil)
dbCreateInst(cv pdb3ac_h_gMaster "VREFP2_right6" '(56.0 15.1875) "R90")
schCreateWire(cv "route" "full" '((56.000 14.999) (56.750 14.999)) 0 0 0 nil nil)
schCreateWireLabel(cv nil '(56.250 14.999) "VREFP2" "lowerLeft" "R0" "stick" 0.0625 nil)
schCreatePin(cv nil "VREFP2" "inputOutput" nil '(56.750 14.999) "R180")
schCreateWire(cv "route" "full" '((55.125 14.938) (54.375 14.938)) 0 0 0 nil nil)
schCreateWireLabel(cv nil '(54.875 14.938) "AVSS3" "lowerRight" "R0" "stick" 0.0625 nil)
schCreateWire(cv "route" "full" '((55.125 15.312) (54.375 15.312)) 0 0 0 nil nil)
schCreateWireLabel(cv nil '(54.875 15.312) "GIOL" "lowerRight" "R0" "stick" 0.0625 nil)
schCreateWire(cv "route" "full" '((55.125 14.562) (54.375 14.562)) 0 0 0 nil nil)
schCreateWireLabel(cv nil '(54.875 14.562) "AVDDH3" "lowerRight" "R0" "stick" 0.0625 nil)
dbCreateInst(cv pdb3ac_h_gMaster "VREFPF3_right7" '(56.0 17.1875) "R90")
schCreateWire(cv "route" "full" '((56.000 17.000) (56.750 17.000)) 0 0 0 nil nil)
schCreateWireLabel(cv nil '(56.250 17.000) "VREFPF3" "lowerLeft" "R0" "stick" 0.0625 nil)
schCreatePin(cv nil "VREFPF3" "inputOutput" nil '(56.750 17.000) "R180")
schCreateWire(cv "route" "full" '((55.125 16.938) (54.375 16.938)) 0 0 0 nil nil)
schCreateWireLabel(cv nil '(54.875 16.938) "AVSS3" "lowerRight" "R0" "stick" 0.0625 nil)
schCreateWire(cv "route" "full" '((55.125 17.312) (54.375 17.312)) 0 0 0 nil nil)
schCreateWireLabel(cv nil '(54.875 17.312) "GIOL" "lowerRight" "R0" "stick" 0.0625 nil)
schCreateWire(cv "route" "full" '((55.125 16.562) (54.375 16.562)) 0 0 0 nil nil)
schCreateWireLabel(cv nil '(54.875 16.562) "AVDDH3" "lowerRight" "R0" "stick" 0.0625 nil)
dbCreateInst(cv pdb3ac_h_gMaster "VREFP3_right8" '(56.0 19.1875) "R90")
schCreateWire(cv "route" "full" '((56.000 19.000) (56.750 19.000)) 0 0 0 nil nil)
schCreateWireLabel(cv nil '(56.250 19.000) "VREFP3" "lowerLeft" "R0" "stick" 0.0625 nil)
schCreatePin(cv nil "VREFP3" "inputOutput" nil '(56.750 19.000) "R180")
schCreateWire(cv "route" "full" '((55.125 18.938) (54.375 18.938)) 0 0 0 nil nil)
schCreateWireLabel(cv nil '(54.875 18.938) "AVSS3" "lowerRight" "R0" "stick" 0.0625 nil)
schCreateWire(cv "route" "full" '((55.125 19.312) (54.375 19.312)) 0 0 0 nil nil)
schCreateWireLabel(cv nil '(54.875 19.312) "GIOL" "lowerRight" "R0" "stick" 0.0625 nil)
schCreateWire(cv "route" "full" '((55.125 18.562) (54.375 18.562)) 0 0 0 nil nil)
schCreateWireLabel(cv nil '(54.875 18.562) "AVDDH3" "lowerRight" "R0" "stick" 0.0625 nil)
dbCreateInst(cv pvdd3ac_h_gMaster "AVDDH3_right9" '(56.0 21.1875) "R90")
schCreateWire(cv "route" "full" '((55.125 20.562) (54.375 20.562)) 0 0 0 nil nil)
schCreateWireLabel(cv nil '(54.875 20.562) "AVDDH3_CORE" "lowerRight" "R0" "stick" 0.0625 nil)
schCreatePin(cv nil "AVDDH3_CORE" "inputOutput" nil '(54.375 20.562) "R0")
schCreateWire(cv "route" "full" '((55.125 20.938) (54.375 20.938)) 0 0 0 nil nil)
schCreateWireLabel(cv nil '(54.875 20.938) "AVSS3" "lowerRight" "R0" "stick" 0.0625 nil)
schCreateWire(cv "route" "full" '((55.125 21.312) (54.375 21.312)) 0 0 0 nil nil)
schCreateWireLabel(cv nil '(54.875 21.312) "GIOL" "lowerRight" "R0" "stick" 0.0625 nil)
schCreateWire(cv "route" "full" '((56.000 21.000) (56.750 21.000)) 0 0 0 nil nil)
schCreateWireLabel(cv nil '(56.250 21.000) "AVDDH3" "lowerLeft" "R0" "stick" 0.0625 nil)
schCreatePin(cv nil "AVDDH3" "inputOutput" nil '(56.750 21.000) "R180")
dbCreateInst(cv pvdd3ac_h_gMaster "AVDDH3_right10" '(56.0 23.1875) "R90")
schCreateWire(cv "route" "full" '((55.125 22.562) (54.375 22.562)) 0 0 0 nil nil)
schCreateWireLabel(cv nil '(54.875 22.562) "AVDDH3_CORE" "lowerRight" "R0" "stick" 0.0625 nil)
schCreatePin(cv nil "AVDDH3_CORE" "inputOutput" nil '(54.375 22.562) "R0")
schCreateWire(cv "route" "full" '((55.125 22.938) (54.375 22.938)) 0 0 0 nil nil)
schCreateWireLabel(cv nil '(54.875 22.938) "AVSS3" "lowerRight" "R0" "stick" 0.0625 nil)
schCreateWire(cv "route" "full" '((55.125 23.312) (54.375 23.312)) 0 0 0 nil nil)
schCreateWireLabel(cv nil '(54.875 23.312) "GIOL" "lowerRight" "R0" "stick" 0.0625 nil)
schCreateWire(cv "route" "full" '((56.000 23.000) (56.750 23.000)) 0 0 0 nil nil)
schCreateWireLabel(cv nil '(56.250 23.000) "AVDDH3" "lowerLeft" "R0" "stick" 0.0625 nil)
schCreatePin(cv nil "AVDDH3" "inputOutput" nil '(56.750 23.000) "R180")
dbCreateInst(cv pvss3ac_h_gMaster "AVSS3_right11" '(56.0 25.1875) "R90")
schCreateWire(cv "route" "full" '((56.000 25.000) (56.750 25.000)) 0 0 0 nil nil)
schCreateWireLabel(cv nil '(56.250 25.000) "AVSS3" "lowerLeft" "R0" "stick" 0.0625 nil)
schCreatePin(cv nil "AVSS3" "inputOutput" nil '(56.750 25.000) "R180")
schCreateWire(cv "route" "full" '((55.125 25.312) (54.375 25.312)) 0 0 0 nil nil)
schCreateWireLabel(cv nil '(54.875 25.312) "GIOL" "lowerRight" "R0" "stick" 0.0625 nil)
schCreateWire(cv "route" "full" '((55.125 24.562) (54.375 24.562)) 0 0 0 nil nil)
schCreateWireLabel(cv nil '(54.875 24.562) "AVSS3_CORE" "lowerRight" "R0" "stick" 0.0625 nil)
schCreatePin(cv nil "AVSS3_CORE" "inputOutput" nil '(54.375 24.562) "R0")
schCreateWire(cv "route" "full" '((55.125 24.938) (54.375 24.938)) 0 0 0 nil nil)
schCreateWireLabel(cv nil '(54.875 24.938) "AVDDH3" "lowerRight" "R0" "stick" 0.0625 nil)
dbCreateInst(cv pvss3ac_v_gMaster "AVSS3_top0" '(52.8125 28.0) "R180")
schCreateWire(cv "route" "full" '((53.001 28.000) (53.001 28.750)) 0 0 0 nil nil)
schCreateWireLabel(cv nil '(53.001 28.250) "AVSS3" "lowerLeft" "R90" "stick" 0.0625 nil)
schCreatePin(cv nil "AVSS3" "inputOutput" nil '(53.001 28.750) "R270")
schCreateWire(cv "route" "full" '((52.688 27.125) (52.688 26.375)) 0 0 0 nil nil)
schCreateWireLabel(cv nil '(52.688 26.875) "GIOL" "lowerRight" "R90" "stick" 0.0625 nil)
schCreateWire(cv "route" "full" '((53.438 27.125) (53.438 26.375)) 0 0 0 nil nil)
schCreateWireLabel(cv nil '(53.438 26.875) "AVSS3_CORE" "lowerRight" "R90" "stick" 0.0625 nil)
schCreatePin(cv nil "AVSS3_CORE" "inputOutput" nil '(53.438 26.375) "R90")
schCreateWire(cv "route" "full" '((53.062 27.125) (53.062 26.375)) 0 0 0 nil nil)
schCreateWireLabel(cv nil '(53.062 26.875) "AVDDH3" "lowerRight" "R90" "stick" 0.0625 nil)
pvss1ac_v_gMaster = dbOpenCellView("tphn28hpcpgv18" "PVSS1AC_V_G" "symbol")
dbCreateInst(cv pvss1ac_v_gMaster "FVSS_top1" '(50.8125 28.0) "R180")
schCreateWire(cv "route" "full" '((51.001 28.000) (51.001 28.750)) 0 0 0 nil nil)
schCreateWireLabel(cv nil '(51.001 28.250) "FVSS" "lowerLeft" "R90" "stick" 0.0625 nil)
schCreatePin(cv nil "FVSS" "inputOutput" nil '(51.001 28.750) "R270")
schCreateWire(cv "route" "full" '((51.062 27.125) (51.062 26.375)) 0 0 0 nil nil)
schCreateWireLabel(cv nil '(51.062 26.875) "AVSS3" "lowerRight" "R90" "stick" 0.0625 nil)
schCreateWire(cv "route" "full" '((50.688 27.125) (50.688 26.375)) 0 0 0 nil nil)
schCreateWireLabel(cv nil '(50.688 26.875) "GIOL" "lowerRight" "R90" "stick" 0.0625 nil)
schCreateWire(cv "route" "full" '((51.438 27.125) (51.438 26.375)) 0 0 0 nil nil)
schCreateWireLabel(cv nil '(51.438 26.875) "AVDDH3" "lowerRight" "R90" "stick" 0.0625 nil)
dbCreateInst(cv pvdd1ac_v_gMaster "FVDDH_top2" '(48.8125 28.0) "R180")
schCreateWire(cv "route" "full" '((49.062 27.125) (49.062 26.375)) 0 0 0 nil nil)
schCreateWireLabel(cv nil '(49.062 26.875) "AVSS3" "lowerRight" "R90" "stick" 0.0625 nil)
schCreateWire(cv "route" "full" '((48.688 27.125) (48.688 26.375)) 0 0 0 nil nil)
schCreateWireLabel(cv nil '(48.688 26.875) "GIOL" "lowerRight" "R90" "stick" 0.0625 nil)
schCreateWire(cv "route" "full" '((49.001 28.000) (49.001 28.750)) 0 0 0 nil nil)
schCreateWireLabel(cv nil '(49.001 28.250) "FVDDH" "lowerLeft" "R90" "stick" 0.0625 nil)
schCreatePin(cv nil "FVDDH" "inputOutput" nil '(49.001 28.750) "R270")
schCreateWire(cv "route" "full" '((49.438 27.125) (49.438 26.375)) 0 0 0 nil nil)
schCreateWireLabel(cv nil '(49.438 26.875) "AVDDH3" "lowerRight" "R90" "stick" 0.0625 nil)
dbCreateInst(cv pvdd1ac_v_gMaster "FVDD_top3" '(46.8125 28.0) "R180")
schCreateWire(cv "route" "full" '((47.062 27.125) (47.062 26.375)) 0 0 0 nil nil)
schCreateWireLabel(cv nil '(47.062 26.875) "AVSS3" "lowerRight" "R90" "stick" 0.0625 nil)
schCreateWire(cv "route" "full" '((46.688 27.125) (46.688 26.375)) 0 0 0 nil nil)
schCreateWireLabel(cv nil '(46.688 26.875) "GIOL" "lowerRight" "R90" "stick" 0.0625 nil)
schCreateWire(cv "route" "full" '((47.001 28.000) (47.001 28.750)) 0 0 0 nil nil)
schCreateWireLabel(cv nil '(47.001 28.250) "FVDD" "lowerLeft" "R90" "stick" 0.0625 nil)
schCreatePin(cv nil "FVDD" "inputOutput" nil '(47.001 28.750) "R270")
schCreateWire(cv "route" "full" '((47.438 27.125) (47.438 26.375)) 0 0 0 nil nil)
schCreateWireLabel(cv nil '(47.438 26.875) "AVDDH3" "lowerRight" "R90" "stick" 0.0625 nil)
dbCreateInst(cv pvss1ac_v_gMaster "VSSFIFO_top4" '(44.8125 28.0) "R180")
schCreateWire(cv "route" "full" '((45.001 28.000) (45.001 28.750)) 0 0 0 nil nil)
schCreateWireLabel(cv nil '(45.001 28.250) "VSSFIFO" "lowerLeft" "R90" "stick" 0.0625 nil)
schCreatePin(cv nil "VSSFIFO" "inputOutput" nil '(45.001 28.750) "R270")
schCreateWire(cv "route" "full" '((45.062 27.125) (45.062 26.375)) 0 0 0 nil nil)
schCreateWireLabel(cv nil '(45.062 26.875) "AVSS3" "lowerRight" "R90" "stick" 0.0625 nil)
schCreateWire(cv "route" "full" '((44.688 27.125) (44.688 26.375)) 0 0 0 nil nil)
schCreateWireLabel(cv nil '(44.688 26.875) "GIOL" "lowerRight" "R90" "stick" 0.0625 nil)
schCreateWire(cv "route" "full" '((45.438 27.125) (45.438 26.375)) 0 0 0 nil nil)
schCreateWireLabel(cv nil '(45.438 26.875) "AVDDH3" "lowerRight" "R90" "stick" 0.0625 nil)
dbCreateInst(cv pvdd1ac_v_gMaster "VDDFIFO_top5" '(42.8125 28.0) "R180")
schCreateWire(cv "route" "full" '((43.062 27.125) (43.062 26.375)) 0 0 0 nil nil)
schCreateWireLabel(cv nil '(43.062 26.875) "AVSS3" "lowerRight" "R90" "stick" 0.0625 nil)
schCreateWire(cv "route" "full" '((42.688 27.125) (42.688 26.375)) 0 0 0 nil nil)
schCreateWireLabel(cv nil '(42.688 26.875) "GIOL" "lowerRight" "R90" "stick" 0.0625 nil)
schCreateWire(cv "route" "full" '((43.001 28.000) (43.001 28.750)) 0 0 0 nil nil)
schCreateWireLabel(cv nil '(43.001 28.250) "VDDFIFO" "lowerLeft" "R90" "stick" 0.0625 nil)
schCreatePin(cv nil "VDDFIFO" "inputOutput" nil '(43.001 28.750) "R270")
schCreateWire(cv "route" "full" '((43.438 27.125) (43.438 26.375)) 0 0 0 nil nil)
schCreateWireLabel(cv nil '(43.438 26.875) "AVDDH3" "lowerRight" "R90" "stick" 0.0625 nil)
dbCreateInst(cv pvdd1ac_v_gMaster "DVDD_top6" '(40.8125 28.0) "R180")
schCreateWire(cv "route" "full" '((41.062 27.125) (41.062 26.375)) 0 0 0 nil nil)
schCreateWireLabel(cv nil '(41.062 26.875) "AVSS3" "lowerRight" "R90" "stick" 0.0625 nil)
schCreateWire(cv "route" "full" '((40.688 27.125) (40.688 26.375)) 0 0 0 nil nil)
schCreateWireLabel(cv nil '(40.688 26.875) "GIOL" "lowerRight" "R90" "stick" 0.0625 nil)
schCreateWire(cv "route" "full" '((41.001 28.000) (41.001 28.750)) 0 0 0 nil nil)
schCreateWireLabel(cv nil '(41.001 28.250) "DVDD" "lowerLeft" "R90" "stick" 0.0625 nil)
schCreatePin(cv nil "DVDD" "inputOutput" nil '(41.001 28.750) "R270")
schCreateWire(cv "route" "full" '((41.438 27.125) (41.438 26.375)) 0 0 0 nil nil)
schCreateWireLabel(cv nil '(41.438 26.875) "AVDDH3" "lowerRight" "R90" "stick" 0.0625 nil)
dbCreateInst(cv pvss1ac_v_gMaster "DVSS_top7" '(38.8125 28.0) "R180")
schCreateWire(cv "route" "full" '((39.001 28.000) (39.001 28.750)) 0 0 0 nil nil)
schCreateWireLabel(cv nil '(39.001 28.250) "DVSS" "lowerLeft" "R90" "stick" 0.0625 nil)
schCreatePin(cv nil "DVSS" "inputOutput" nil '(39.001 28.750) "R270")
schCreateWire(cv "route" "full" '((39.062 27.125) (39.062 26.375)) 0 0 0 nil nil)
schCreateWireLabel(cv nil '(39.062 26.875) "AVSS3" "lowerRight" "R90" "stick" 0.0625 nil)
schCreateWire(cv "route" "full" '((38.688 27.125) (38.688 26.375)) 0 0 0 nil nil)
schCreateWireLabel(cv nil '(38.688 26.875) "GIOL" "lowerRight" "R90" "stick" 0.0625 nil)
schCreateWire(cv "route" "full" '((39.438 27.125) (39.438 26.375)) 0 0 0 nil nil)
schCreateWireLabel(cv nil '(39.438 26.875) "AVDDH3" "lowerRight" "R90" "stick" 0.0625 nil)
pvss1dgz_v_gMaster = dbOpenCellView("tphn28hpcpgv18" "PVSS1DGZ_V_G" "symbol")
dbCreateInst(cv pvss1dgz_v_gMaster "GIOL_top8" '(38.0 28.0) "R180")
schCreateWire(cv "route" "full" '((37.625 27.000) (37.625 26.250)) 0 0 0 nil nil)
schCreateWireLabel(cv nil '(37.625 26.750) "POC" "lowerRight" "R90" "stick" 0.0625 nil)
schCreateWire(cv "route" "full" '((37.438 27.000) (37.438 26.250)) 0 0 0 nil nil)
schCreateWireLabel(cv nil '(37.438 26.750) "VIOL" "lowerRight" "R90" "stick" 0.0625 nil)
schCreateWire(cv "route" "full" '((37.000 28.000) (37.000 28.750)) 0 0 0 nil nil)
schCreateWireLabel(cv nil '(37.000 28.250) "GIOL" "lowerLeft" "R90" "stick" 0.0625 nil)
schCreatePin(cv nil "GIOL" "inputOutput" nil '(37.000 28.750) "R270")
schCreateWire(cv "route" "full" '((37.062 27.000) (37.062 26.250)) 0 0 0 nil nil)
schCreateWireLabel(cv nil '(37.062 26.750) "VIOH" "lowerRight" "R90" "stick" 0.0625 nil)
schCreateWire(cv "route" "full" '((36.688 27.000) (36.688 26.250)) 0 0 0 nil nil)
schCreateWireLabel(cv nil '(36.688 26.750) "GIOH" "lowerRight" "R90" "stick" 0.0625 nil)
pvdd2poc_v_gMaster = dbOpenCellView("tphn28hpcpgv18" "PVDD2POC_V_G" "symbol")
dbCreateInst(cv pvdd2poc_v_gMaster "VIOH_top9" '(36.0 28.0) "R180")
schCreateWire(cv "route" "full" '((35.625 27.000) (35.625 26.250)) 0 0 0 nil nil)
schCreateWireLabel(cv nil '(35.625 26.750) "POC" "lowerRight" "R90" "stick" 0.0625 nil)
schCreateWire(cv "route" "full" '((35.438 27.000) (35.438 26.250)) 0 0 0 nil nil)
schCreateWireLabel(cv nil '(35.438 26.750) "VIOL" "lowerRight" "R90" "stick" 0.0625 nil)
schCreateWire(cv "route" "full" '((35.250 27.000) (35.250 26.250)) 0 0 0 nil nil)
schCreateWireLabel(cv nil '(35.250 26.750) "GIOL" "lowerRight" "R90" "stick" 0.0625 nil)
schCreateWire(cv "route" "full" '((35.000 28.000) (35.000 28.750)) 0 0 0 nil nil)
schCreateWireLabel(cv nil '(35.000 28.250) "VIOH" "lowerLeft" "R90" "stick" 0.0625 nil)
schCreatePin(cv nil "VIOH" "inputOutput" nil '(35.000 28.750) "R270")
schCreateWire(cv "route" "full" '((34.688 27.000) (34.688 26.250)) 0 0 0 nil nil)
schCreateWireLabel(cv nil '(34.688 26.750) "GIOH" "lowerRight" "R90" "stick" 0.0625 nil)
pddw16sdgz_v_gMaster = dbOpenCellView("tphn28hpcpgv18" "PDDW16SDGZ_V_G" "symbol")
dbCreateInst(cv pddw16sdgz_v_gMaster "SCK_top10" '(33.6875 28.0) "R180")
schCreateWire(cv "route" "full" '((33.562 27.000) (33.562 26.250)) 0 0 0 nil nil)
schCreateWireLabel(cv nil '(33.562 26.750) "GIOL" "lowerRight" "R90" "stick" 0.0625 nil)
schCreateWire(cv "route" "full" '((33.438 27.000) (33.438 26.250)) 0 0 0 nil nil)
schCreateWireLabel(cv nil '(33.438 26.750) "SCK_CORE" "lowerRight" "R90" "stick" 0.0625 nil)
schCreatePin(cv nil "SCK_CORE" "inputOutput" nil '(33.438 26.250) "R90")
schCreateWire(cv "route" "full" '((33.812 27.000) (33.812 26.250)) 0 0 0 nil nil)
schCreateWireLabel(cv nil '(33.812 26.750) "VIOL" "lowerRight" "R90" "stick" 0.0625 nil)
schCreateWire(cv "route" "full" '((33.938 27.000) (33.938 26.250)) 0 0 0 nil nil)
schCreateWireLabel(cv nil '(33.938 26.750) "GIOL" "lowerRight" "R90" "stick" 0.0625 nil)
schCreateWire(cv "route" "full" '((32.999 28.000) (32.999 28.750)) 0 0 0 nil nil)
schCreateWireLabel(cv nil '(32.999 28.250) "SCK" "lowerLeft" "R90" "stick" 0.0625 nil)
schCreatePin(cv nil "SCK" "inputOutput" nil '(32.999 28.750) "R270")
schCreateWire(cv "route" "full" '((33.312 27.000) (33.312 26.250)) 0 0 0 nil nil)
schCreateWireLabel(cv nil '(33.312 26.750) "POC" "lowerRight" "R90" "stick" 0.0625 nil)
schCreateWire(cv "route" "full" '((33.126 27.000) (33.126 26.250)) 0 0 0 nil nil)
schCreateWireLabel(cv nil '(33.126 26.750) "VIOL" "lowerRight" "R90" "stick" 0.0625 nil)
schCreateWire(cv "route" "full" '((32.938 27.000) (32.938 26.250)) 0 0 0 nil nil)
schCreateWireLabel(cv nil '(32.938 26.750) "GIOL" "lowerRight" "R90" "stick" 0.0625 nil)
schCreateWire(cv "route" "full" '((32.749 27.000) (32.749 26.250)) 0 0 0 nil nil)
schCreateWireLabel(cv nil '(32.749 26.750) "VIOH" "lowerRight" "R90" "stick" 0.0625 nil)
schCreateWire(cv "route" "full" '((32.376 27.000) (32.376 26.250)) 0 0 0 nil nil)
schCreateWireLabel(cv nil '(32.376 26.750) "GIOH" "lowerRight" "R90" "stick" 0.0625 nil)
dbCreateInst(cv pddw16sdgz_v_gMaster "SEL_1_top11" '(31.6875 28.0) "R180")
schCreateWire(cv "route" "full" '((31.562 27.000) (31.562 26.250)) 0 0 0 nil nil)
schCreateWireLabel(cv nil '(31.562 26.750) "GIOL" "lowerRight" "R90" "stick" 0.0625 nil)
schCreateWire(cv "route" "full" '((31.438 27.000) (31.438 26.250)) 0 0 0 nil nil)
schCreateWireLabel(cv nil '(31.438 26.750) "SEL_CORE<1>" "lowerRight" "R90" "stick" 0.0625 nil)
schCreatePin(cv nil "SEL_CORE<1>" "inputOutput" nil '(31.438 26.250) "R90")
schCreateWire(cv "route" "full" '((31.812 27.000) (31.812 26.250)) 0 0 0 nil nil)
schCreateWireLabel(cv nil '(31.812 26.750) "VIOL" "lowerRight" "R90" "stick" 0.0625 nil)
schCreateWire(cv "route" "full" '((31.938 27.000) (31.938 26.250)) 0 0 0 nil nil)
schCreateWireLabel(cv nil '(31.938 26.750) "GIOL" "lowerRight" "R90" "stick" 0.0625 nil)
schCreateWire(cv "route" "full" '((31.000 28.000) (31.000 28.750)) 0 0 0 nil nil)
schCreateWireLabel(cv nil '(31.000 28.250) "SEL<1>" "lowerLeft" "R90" "stick" 0.0625 nil)
schCreatePin(cv nil "SEL<1>" "inputOutput" nil '(31.000 28.750) "R270")
schCreateWire(cv "route" "full" '((31.312 27.000) (31.312 26.250)) 0 0 0 nil nil)
schCreateWireLabel(cv nil '(31.312 26.750) "POC" "lowerRight" "R90" "stick" 0.0625 nil)
schCreateWire(cv "route" "full" '((31.125 27.000) (31.125 26.250)) 0 0 0 nil nil)
schCreateWireLabel(cv nil '(31.125 26.750) "VIOL" "lowerRight" "R90" "stick" 0.0625 nil)
schCreateWire(cv "route" "full" '((30.938 27.000) (30.938 26.250)) 0 0 0 nil nil)
schCreateWireLabel(cv nil '(30.938 26.750) "GIOL" "lowerRight" "R90" "stick" 0.0625 nil)
schCreateWire(cv "route" "full" '((30.750 27.000) (30.750 26.250)) 0 0 0 nil nil)
schCreateWireLabel(cv nil '(30.750 26.750) "VIOH" "lowerRight" "R90" "stick" 0.0625 nil)
schCreateWire(cv "route" "full" '((30.375 27.000) (30.375 26.250)) 0 0 0 nil nil)
schCreateWireLabel(cv nil '(30.375 26.750) "GIOH" "lowerRight" "R90" "stick" 0.0625 nil)
dbCreateInst(cv pddw16sdgz_v_gMaster "TRIG_top12" '(29.6875 28.0) "R180")
schCreateWire(cv "route" "full" '((29.562 27.000) (29.562 26.250)) 0 0 0 nil nil)
schCreateWireLabel(cv nil '(29.562 26.750) "GIOL" "lowerRight" "R90" "stick" 0.0625 nil)
schCreateWire(cv "route" "full" '((29.438 27.000) (29.438 26.250)) 0 0 0 nil nil)
schCreateWireLabel(cv nil '(29.438 26.750) "TRIG_CORE" "lowerRight" "R90" "stick" 0.0625 nil)
schCreatePin(cv nil "TRIG_CORE" "inputOutput" nil '(29.438 26.250) "R90")
schCreateWire(cv "route" "full" '((29.812 27.000) (29.812 26.250)) 0 0 0 nil nil)
schCreateWireLabel(cv nil '(29.812 26.750) "VIOL" "lowerRight" "R90" "stick" 0.0625 nil)
schCreateWire(cv "route" "full" '((29.938 27.000) (29.938 26.250)) 0 0 0 nil nil)
schCreateWireLabel(cv nil '(29.938 26.750) "GIOL" "lowerRight" "R90" "stick" 0.0625 nil)
schCreateWire(cv "route" "full" '((29.000 28.000) (29.000 28.750)) 0 0 0 nil nil)
schCreateWireLabel(cv nil '(29.000 28.250) "TRIG" "lowerLeft" "R90" "stick" 0.0625 nil)
schCreatePin(cv nil "TRIG" "inputOutput" nil '(29.000 28.750) "R270")
schCreateWire(cv "route" "full" '((29.312 27.000) (29.312 26.250)) 0 0 0 nil nil)
schCreateWireLabel(cv nil '(29.312 26.750) "POC" "lowerRight" "R90" "stick" 0.0625 nil)
schCreateWire(cv "route" "full" '((29.125 27.000) (29.125 26.250)) 0 0 0 nil nil)
schCreateWireLabel(cv nil '(29.125 26.750) "VIOL" "lowerRight" "R90" "stick" 0.0625 nil)
schCreateWire(cv "route" "full" '((28.938 27.000) (28.938 26.250)) 0 0 0 nil nil)
schCreateWireLabel(cv nil '(28.938 26.750) "GIOL" "lowerRight" "R90" "stick" 0.0625 nil)
schCreateWire(cv "route" "full" '((28.750 27.000) (28.750 26.250)) 0 0 0 nil nil)
schCreateWireLabel(cv nil '(28.750 26.750) "VIOH" "lowerRight" "R90" "stick" 0.0625 nil)
schCreateWire(cv "route" "full" '((28.375 27.000) (28.375 26.250)) 0 0 0 nil nil)
schCreateWireLabel(cv nil '(28.375 26.750) "GIOH" "lowerRight" "R90" "stick" 0.0625 nil)
dbCreateInst(cv pddw16sdgz_v_gMaster "CLKO_top13" '(27.6875 28.0) "R180")
schCreateWire(cv "route" "full" '((27.562 27.000) (27.562 26.250)) 0 0 0 nil nil)
schCreateWireLabel(cv nil '(27.562 26.750) "VIOL" "lowerRight" "R90" "stick" 0.0625 nil)
noConnMaster = dbOpenCellView("basic" "noConn" "symbol")
schCreateWire(cv "route" "full" '((27.438 27.000) (27.438 26.250)) 0 0 0 nil nil)
dbCreateInst(cv noConnMaster "noConn_CLKO_top13_C" '(27.438 26.250) "R0")
schCreateWire(cv "route" "full" '((27.812 27.000) (27.812 26.250)) 0 0 0 nil nil)
schCreateWireLabel(cv nil '(27.812 26.750) "GIOL" "lowerRight" "R90" "stick" 0.0625 nil)
schCreateWire(cv "route" "full" '((27.938 27.000) (27.938 26.250)) 0 0 0 nil nil)
schCreateWireLabel(cv nil '(27.938 26.750) "CLKO_CORE" "lowerRight" "R90" "stick" 0.0625 nil)
schCreatePin(cv nil "CLKO_CORE" "inputOutput" nil '(27.938 26.250) "R90")
schCreateWire(cv "route" "full" '((27.000 28.000) (27.000 28.750)) 0 0 0 nil nil)
schCreateWireLabel(cv nil '(27.000 28.250) "CLKO" "lowerLeft" "R90" "stick" 0.0625 nil)
schCreatePin(cv nil "CLKO" "inputOutput" nil '(27.000 28.750) "R270")
schCreateWire(cv "route" "full" '((27.312 27.000) (27.312 26.250)) 0 0 0 nil nil)
schCreateWireLabel(cv nil '(27.312 26.750) "POC" "lowerRight" "R90" "stick" 0.0625 nil)
schCreateWire(cv "route" "full" '((27.125 27.000) (27.125 26.250)) 0 0 0 nil nil)
schCreateWireLabel(cv nil '(27.125 26.750) "VIOL" "lowerRight" "R90" "stick" 0.0625 nil)
schCreateWire(cv "route" "full" '((26.938 27.000) (26.938 26.250)) 0 0 0 nil nil)
schCreateWireLabel(cv nil '(26.938 26.750) "GIOL" "lowerRight" "R90" "stick" 0.0625 nil)
schCreateWire(cv "route" "full" '((26.750 27.000) (26.750 26.250)) 0 0 0 nil nil)
schCreateWireLabel(cv nil '(26.750 26.750) "VIOH" "lowerRight" "R90" "stick" 0.0625 nil)
schCreateWire(cv "route" "full" '((26.375 27.000) (26.375 26.250)) 0 0 0 nil nil)
schCreateWireLabel(cv nil '(26.375 26.750) "GIOH" "lowerRight" "R90" "stick" 0.0625 nil)
dbCreateInst(cv pddw16sdgz_v_gMaster "D_1_top14" '(25.6875 28.0) "R180")
schCreateWire(cv "route" "full" '((25.562 27.000) (25.562 26.250)) 0 0 0 nil nil)
schCreateWireLabel(cv nil '(25.562 26.750) "VIOL" "lowerRight" "R90" "stick" 0.0625 nil)
schCreateWire(cv "route" "full" '((25.438 27.000) (25.438 26.250)) 0 0 0 nil nil)
dbCreateInst(cv noConnMaster "noConn_D_1_top14_C" '(25.438 26.250) "R0")
schCreateWire(cv "route" "full" '((25.812 27.000) (25.812 26.250)) 0 0 0 nil nil)
schCreateWireLabel(cv nil '(25.812 26.750) "GIOL" "lowerRight" "R90" "stick" 0.0625 nil)
schCreateWire(cv "route" "full" '((25.938 27.000) (25.938 26.250)) 0 0 0 nil nil)
schCreateWireLabel(cv nil '(25.938 26.750) "D_CORE<1>" "lowerRight" "R90" "stick" 0.0625 nil)
schCreatePin(cv nil "D_CORE<1>" "inputOutput" nil '(25.938 26.250) "R90")
schCreateWire(cv "route" "full" '((25.000 28.000) (25.000 28.750)) 0 0 0 nil nil)
schCreateWireLabel(cv nil '(25.000 28.250) "D<1>" "lowerLeft" "R90" "stick" 0.0625 nil)
schCreatePin(cv nil "D<1>" "inputOutput" nil '(25.000 28.750) "R270")
schCreateWire(cv "route" "full" '((25.312 27.000) (25.312 26.250)) 0 0 0 nil nil)
schCreateWireLabel(cv nil '(25.312 26.750) "POC" "lowerRight" "R90" "stick" 0.0625 nil)
schCreateWire(cv "route" "full" '((25.125 27.000) (25.125 26.250)) 0 0 0 nil nil)
schCreateWireLabel(cv nil '(25.125 26.750) "VIOL" "lowerRight" "R90" "stick" 0.0625 nil)
schCreateWire(cv "route" "full" '((24.938 27.000) (24.938 26.250)) 0 0 0 nil nil)
schCreateWireLabel(cv nil '(24.938 26.750) "GIOL" "lowerRight" "R90" "stick" 0.0625 nil)
schCreateWire(cv "route" "full" '((24.750 27.000) (24.750 26.250)) 0 0 0 nil nil)
schCreateWireLabel(cv nil '(24.750 26.750) "VIOH" "lowerRight" "R90" "stick" 0.0625 nil)
schCreateWire(cv "route" "full" '((24.375 27.000) (24.375 26.250)) 0 0 0 nil nil)
schCreateWireLabel(cv nil '(24.375 26.750) "GIOH" "lowerRight" "R90" "stick" 0.0625 nil)
dbCreateInst(cv pddw16sdgz_v_gMaster "D_3_top15" '(23.6875 28.0) "R180")
schCreateWire(cv "route" "full" '((23.562 27.000) (23.562 26.250)) 0 0 0 nil nil)
schCreateWireLabel(cv nil '(23.562 26.750) "VIOL" "lowerRight" "R90" "stick" 0.0625 nil)
schCreateWire(cv "route" "full" '((23.438 27.000) (23.438 26.250)) 0 0 0 nil nil)
dbCreateInst(cv noConnMaster "noConn_D_3_top15_C" '(23.438 26.250) "R0")
schCreateWire(cv "route" "full" '((23.812 27.000) (23.812 26.250)) 0 0 0 nil nil)
schCreateWireLabel(cv nil '(23.812 26.750) "GIOL" "lowerRight" "R90" "stick" 0.0625 nil)
schCreateWire(cv "route" "full" '((23.938 27.000) (23.938 26.250)) 0 0 0 nil nil)
schCreateWireLabel(cv nil '(23.938 26.750) "D_CORE<3>" "lowerRight" "R90" "stick" 0.0625 nil)
schCreatePin(cv nil "D_CORE<3>" "inputOutput" nil '(23.938 26.250) "R90")
schCreateWire(cv "route" "full" '((23.000 28.000) (23.000 28.750)) 0 0 0 nil nil)
schCreateWireLabel(cv nil '(23.000 28.250) "D<3>" "lowerLeft" "R90" "stick" 0.0625 nil)
schCreatePin(cv nil "D<3>" "inputOutput" nil '(23.000 28.750) "R270")
schCreateWire(cv "route" "full" '((23.312 27.000) (23.312 26.250)) 0 0 0 nil nil)
schCreateWireLabel(cv nil '(23.312 26.750) "POC" "lowerRight" "R90" "stick" 0.0625 nil)
schCreateWire(cv "route" "full" '((23.125 27.000) (23.125 26.250)) 0 0 0 nil nil)
schCreateWireLabel(cv nil '(23.125 26.750) "VIOL" "lowerRight" "R90" "stick" 0.0625 nil)
schCreateWire(cv "route" "full" '((22.938 27.000) (22.938 26.250)) 0 0 0 nil nil)
schCreateWireLabel(cv nil '(22.938 26.750) "GIOL" "lowerRight" "R90" "stick" 0.0625 nil)
schCreateWire(cv "route" "full" '((22.750 27.000) (22.750 26.250)) 0 0 0 nil nil)
schCreateWireLabel(cv nil '(22.750 26.750) "VIOH" "lowerRight" "R90" "stick" 0.0625 nil)
schCreateWire(cv "route" "full" '((22.375 27.000) (22.375 26.250)) 0 0 0 nil nil)
schCreateWireLabel(cv nil '(22.375 26.750) "GIOH" "lowerRight" "R90" "stick" 0.0625 nil)
dbCreateInst(cv pddw16sdgz_v_gMaster "FLAG_top16" '(21.6875 28.0) "R180")
schCreateWire(cv "route" "full" '((21.562 27.000) (21.562 26.250)) 0 0 0 nil nil)
schCreateWireLabel(cv nil '(21.562 26.750) "VIOL" "lowerRight" "R90" "stick" 0.0625 nil)
schCreateWire(cv "route" "full" '((21.438 27.000) (21.438 26.250)) 0 0 0 nil nil)
dbCreateInst(cv noConnMaster "noConn_FLAG_top16_C" '(21.438 26.250) "R0")
schCreateWire(cv "route" "full" '((21.812 27.000) (21.812 26.250)) 0 0 0 nil nil)
schCreateWireLabel(cv nil '(21.812 26.750) "GIOL" "lowerRight" "R90" "stick" 0.0625 nil)
schCreateWire(cv "route" "full" '((21.938 27.000) (21.938 26.250)) 0 0 0 nil nil)
schCreateWireLabel(cv nil '(21.938 26.750) "FLAG_CORE" "lowerRight" "R90" "stick" 0.0625 nil)
schCreatePin(cv nil "FLAG_CORE" "inputOutput" nil '(21.938 26.250) "R90")
schCreateWire(cv "route" "full" '((21.000 28.000) (21.000 28.750)) 0 0 0 nil nil)
schCreateWireLabel(cv nil '(21.000 28.250) "FLAG" "lowerLeft" "R90" "stick" 0.0625 nil)
schCreatePin(cv nil "FLAG" "inputOutput" nil '(21.000 28.750) "R270")
schCreateWire(cv "route" "full" '((21.312 27.000) (21.312 26.250)) 0 0 0 nil nil)
schCreateWireLabel(cv nil '(21.312 26.750) "POC" "lowerRight" "R90" "stick" 0.0625 nil)
schCreateWire(cv "route" "full" '((21.125 27.000) (21.125 26.250)) 0 0 0 nil nil)
schCreateWireLabel(cv nil '(21.125 26.750) "VIOL" "lowerRight" "R90" "stick" 0.0625 nil)
schCreateWire(cv "route" "full" '((20.938 27.000) (20.938 26.250)) 0 0 0 nil nil)
schCreateWireLabel(cv nil '(20.938 26.750) "GIOL" "lowerRight" "R90" "stick" 0.0625 nil)
schCreateWire(cv "route" "full" '((20.750 27.000) (20.750 26.250)) 0 0 0 nil nil)
schCreateWireLabel(cv nil '(20.750 26.750) "VIOH" "lowerRight" "R90" "stick" 0.0625 nil)
schCreateWire(cv "route" "full" '((20.375 27.000) (20.375 26.250)) 0 0 0 nil nil)
schCreateWireLabel(cv nil '(20.375 26.750) "GIOH" "lowerRight" "R90" "stick" 0.0625 nil)
dbCreateInst(cv pddw16sdgz_v_gMaster "SDI_top17" '(19.6875 28.0) "R180")
schCreateWire(cv "route" "full" '((19.562 27.000) (19.562 26.250)) 0 0 0 nil nil)
schCreateWireLabel(cv nil '(19.562 26.750) "GIOL" "lowerRight" "R90" "stick" 0.0625 nil)
schCreateWire(cv "route" "full" '((19.438 27.000) (19.438 26.250)) 0 0 0 nil nil)
schCreateWireLabel(cv nil '(19.438 26.750) "SDI_CORE" "lowerRight" "R90" "stick" 0.0625 nil)
schCreatePin(cv nil "SDI_CORE" "inputOutput" nil '(19.438 26.250) "R90")
schCreateWire(cv "route" "full" '((19.812 27.000) (19.812 26.250)) 0 0 0 nil nil)
schCreateWireLabel(cv nil '(19.812 26.750) "VIOL" "lowerRight" "R90" "stick" 0.0625 nil)
schCreateWire(cv "route" "full" '((19.938 27.000) (19.938 26.250)) 0 0 0 nil nil)
schCreateWireLabel(cv nil '(19.938 26.750) "GIOL" "lowerRight" "R90" "stick" 0.0625 nil)
schCreateWire(cv "route" "full" '((19.000 28.000) (19.000 28.750)) 0 0 0 nil nil)
schCreateWireLabel(cv nil '(19.000 28.250) "SDI" "lowerLeft" "R90" "stick" 0.0625 nil)
schCreatePin(cv nil "SDI" "inputOutput" nil '(19.000 28.750) "R270")
schCreateWire(cv "route" "full" '((19.312 27.000) (19.312 26.250)) 0 0 0 nil nil)
schCreateWireLabel(cv nil '(19.312 26.750) "POC" "lowerRight" "R90" "stick" 0.0625 nil)
schCreateWire(cv "route" "full" '((19.125 27.000) (19.125 26.250)) 0 0 0 nil nil)
schCreateWireLabel(cv nil '(19.125 26.750) "VIOL" "lowerRight" "R90" "stick" 0.0625 nil)
schCreateWire(cv "route" "full" '((18.938 27.000) (18.938 26.250)) 0 0 0 nil nil)
schCreateWireLabel(cv nil '(18.938 26.750) "GIOL" "lowerRight" "R90" "stick" 0.0625 nil)
schCreateWire(cv "route" "full" '((18.750 27.000) (18.750 26.250)) 0 0 0 nil nil)
schCreateWireLabel(cv nil '(18.750 26.750) "VIOH" "lowerRight" "R90" "stick" 0.0625 nil)
schCreateWire(cv "route" "full" '((18.375 27.000) (18.375 26.250)) 0 0 0 nil nil)
schCreateWireLabel(cv nil '(18.375 26.750) "GIOH" "lowerRight" "R90" "stick" 0.0625 nil)
dbCreateInst(cv pvss1ac_v_gMaster "DVSS_top18" '(16.8125 28.0) "R180")
schCreateWire(cv "route" "full" '((17.000 28.000) (17.000 28.750)) 0 0 0 nil nil)
schCreateWireLabel(cv nil '(17.000 28.250) "DVSS" "lowerLeft" "R90" "stick" 0.0625 nil)
schCreatePin(cv nil "DVSS" "inputOutput" nil '(17.000 28.750) "R270")
schCreateWire(cv "route" "full" '((17.062 27.125) (17.062 26.375)) 0 0 0 nil nil)
schCreateWireLabel(cv nil '(17.062 26.875) "AVSS2" "lowerRight" "R90" "stick" 0.0625 nil)
schCreateWire(cv "route" "full" '((16.688 27.125) (16.688 26.375)) 0 0 0 nil nil)
schCreateWireLabel(cv nil '(16.688 26.875) "GIOL" "lowerRight" "R90" "stick" 0.0625 nil)
schCreateWire(cv "route" "full" '((17.438 27.125) (17.438 26.375)) 0 0 0 nil nil)
schCreateWireLabel(cv nil '(17.438 26.875) "AVDDH2" "lowerRight" "R90" "stick" 0.0625 nil)
dbCreateInst(cv pvdd1ac_v_gMaster "DVDD_top19" '(14.8125 28.0) "R180")
schCreateWire(cv "route" "full" '((15.062 27.125) (15.062 26.375)) 0 0 0 nil nil)
schCreateWireLabel(cv nil '(15.062 26.875) "AVSS2" "lowerRight" "R90" "stick" 0.0625 nil)
schCreateWire(cv "route" "full" '((14.688 27.125) (14.688 26.375)) 0 0 0 nil nil)
schCreateWireLabel(cv nil '(14.688 26.875) "GIOL" "lowerRight" "R90" "stick" 0.0625 nil)
schCreateWire(cv "route" "full" '((15.001 28.000) (15.001 28.750)) 0 0 0 nil nil)
schCreateWireLabel(cv nil '(15.001 28.250) "DVDD" "lowerLeft" "R90" "stick" 0.0625 nil)
schCreatePin(cv nil "DVDD" "inputOutput" nil '(15.001 28.750) "R270")
schCreateWire(cv "route" "full" '((15.438 27.125) (15.438 26.375)) 0 0 0 nil nil)
schCreateWireLabel(cv nil '(15.438 26.875) "AVDDH2" "lowerRight" "R90" "stick" 0.0625 nil)
dbCreateInst(cv pvdd1ac_v_gMaster "VDDCAL_top20" '(12.8125 28.0) "R180")
schCreateWire(cv "route" "full" '((13.062 27.125) (13.062 26.375)) 0 0 0 nil nil)
schCreateWireLabel(cv nil '(13.062 26.875) "AVSS2" "lowerRight" "R90" "stick" 0.0625 nil)
schCreateWire(cv "route" "full" '((12.688 27.125) (12.688 26.375)) 0 0 0 nil nil)
schCreateWireLabel(cv nil '(12.688 26.875) "GIOL" "lowerRight" "R90" "stick" 0.0625 nil)
schCreateWire(cv "route" "full" '((13.001 28.000) (13.001 28.750)) 0 0 0 nil nil)
schCreateWireLabel(cv nil '(13.001 28.250) "VDDCAL" "lowerLeft" "R90" "stick" 0.0625 nil)
schCreatePin(cv nil "VDDCAL" "inputOutput" nil '(13.001 28.750) "R270")
schCreateWire(cv "route" "full" '((13.438 27.125) (13.438 26.375)) 0 0 0 nil nil)
schCreateWireLabel(cv nil '(13.438 26.875) "AVDDH2" "lowerRight" "R90" "stick" 0.0625 nil)
dbCreateInst(cv pvss1ac_v_gMaster "VSSCAL_top21" '(10.8125 28.0) "R180")
schCreateWire(cv "route" "full" '((11.001 28.000) (11.001 28.750)) 0 0 0 nil nil)
schCreateWireLabel(cv nil '(11.001 28.250) "VSSCAL" "lowerLeft" "R90" "stick" 0.0625 nil)
schCreatePin(cv nil "VSSCAL" "inputOutput" nil '(11.001 28.750) "R270")
schCreateWire(cv "route" "full" '((11.062 27.125) (11.062 26.375)) 0 0 0 nil nil)
schCreateWireLabel(cv nil '(11.062 26.875) "AVSS2" "lowerRight" "R90" "stick" 0.0625 nil)
schCreateWire(cv "route" "full" '((10.688 27.125) (10.688 26.375)) 0 0 0 nil nil)
schCreateWireLabel(cv nil '(10.688 26.875) "GIOL" "lowerRight" "R90" "stick" 0.0625 nil)
schCreateWire(cv "route" "full" '((11.438 27.125) (11.438 26.375)) 0 0 0 nil nil)
schCreateWireLabel(cv nil '(11.438 26.875) "AVDDH2" "lowerRight" "R90" "stick" 0.0625 nil)
dbCreateInst(cv pvdd1ac_v_gMaster "VDDSPI_top22" '(8.8125 28.0) "R180")
schCreateWire(cv "route" "full" '((9.062 27.125) (9.062 26.375)) 0 0 0 nil nil)
schCreateWireLabel(cv nil '(9.062 26.875) "AVSS2" "lowerRight" "R90" "stick" 0.0625 nil)
schCreateWire(cv "route" "full" '((8.688 27.125) (8.688 26.375)) 0 0 0 nil nil)
schCreateWireLabel(cv nil '(8.688 26.875) "GIOL" "lowerRight" "R90" "stick" 0.0625 nil)
schCreateWire(cv "route" "full" '((9.001 28.000) (9.001 28.750)) 0 0 0 nil nil)
schCreateWireLabel(cv nil '(9.001 28.250) "VDDSPI" "lowerLeft" "R90" "stick" 0.0625 nil)
schCreatePin(cv nil "VDDSPI" "inputOutput" nil '(9.001 28.750) "R270")
schCreateWire(cv "route" "full" '((9.438 27.125) (9.438 26.375)) 0 0 0 nil nil)
schCreateWireLabel(cv nil '(9.438 26.875) "AVDDH2" "lowerRight" "R90" "stick" 0.0625 nil)
dbCreateInst(cv pvss1ac_v_gMaster "VSSSPI_top23" '(6.8125 28.0) "R180")
schCreateWire(cv "route" "full" '((7.000 28.000) (7.000 28.750)) 0 0 0 nil nil)
schCreateWireLabel(cv nil '(7.000 28.250) "VSSSPI" "lowerLeft" "R90" "stick" 0.0625 nil)
schCreatePin(cv nil "VSSSPI" "inputOutput" nil '(7.000 28.750) "R270")
schCreateWire(cv "route" "full" '((7.062 27.125) (7.062 26.375)) 0 0 0 nil nil)
schCreateWireLabel(cv nil '(7.062 26.875) "AVSS2" "lowerRight" "R90" "stick" 0.0625 nil)
schCreateWire(cv "route" "full" '((6.688 27.125) (6.688 26.375)) 0 0 0 nil nil)
schCreateWireLabel(cv nil '(6.688 26.875) "GIOL" "lowerRight" "R90" "stick" 0.0625 nil)
schCreateWire(cv "route" "full" '((7.438 27.125) (7.438 26.375)) 0 0 0 nil nil)
schCreateWireLabel(cv nil '(7.438 26.875) "AVDDH2" "lowerRight" "R90" "stick" 0.0625 nil)
dbCreateInst(cv pvdd1ac_v_gMaster "VDDFIFO_top24" '(4.8125 28.0) "R180")
schCreateWire(cv "route" "full" '((5.062 27.125) (5.062 26.375)) 0 0 0 nil nil)
schCreateWireLabel(cv nil '(5.062 26.875) "AVSS2" "lowerRight" "R90" "stick" 0.0625 nil)
schCreateWire(cv "route" "full" '((4.688 27.125) (4.688 26.375)) 0 0 0 nil nil)
schCreateWireLabel(cv nil '(4.688 26.875) "GIOL" "lowerRight" "R90" "stick" 0.0625 nil)
schCreateWire(cv "route" "full" '((5.000 28.000) (5.000 28.750)) 0 0 0 nil nil)
schCreateWireLabel(cv nil '(5.000 28.250) "VDDFIFO" "lowerLeft" "R90" "stick" 0.0625 nil)
schCreatePin(cv nil "VDDFIFO" "inputOutput" nil '(5.000 28.750) "R270")
schCreateWire(cv "route" "full" '((5.438 27.125) (5.438 26.375)) 0 0 0 nil nil)
schCreateWireLabel(cv nil '(5.438 26.875) "AVDDH2" "lowerRight" "R90" "stick" 0.0625 nil)
dbCreateInst(cv pvss1ac_v_gMaster "VSSFIFO_top25" '(2.8125 28.0) "R180")
schCreateWire(cv "route" "full" '((3.001 28.000) (3.001 28.750)) 0 0 0 nil nil)
schCreateWireLabel(cv nil '(3.001 28.250) "VSSFIFO" "lowerLeft" "R90" "stick" 0.0625 nil)
schCreatePin(cv nil "VSSFIFO" "inputOutput" nil '(3.001 28.750) "R270")
schCreateWire(cv "route" "full" '((3.062 27.125) (3.062 26.375)) 0 0 0 nil nil)
schCreateWireLabel(cv nil '(3.062 26.875) "AVSS2" "lowerRight" "R90" "stick" 0.0625 nil)
schCreateWire(cv "route" "full" '((2.688 27.125) (2.688 26.375)) 0 0 0 nil nil)
schCreateWireLabel(cv nil '(2.688 26.875) "GIOL" "lowerRight" "R90" "stick" 0.0625 nil)
schCreateWire(cv "route" "full" '((3.438 27.125) (3.438 26.375)) 0 0 0 nil nil)
schCreateWireLabel(cv nil '(3.438 26.875) "AVDDH2" "lowerRight" "R90" "stick" 0.0625 nil)
dbCreateInst(cv pdb3ac_h_gMaster "IBOTA2_left78" '(-4.0 9.625) "R270")
schCreateWire(cv "route" "full" '((-4.000 9.813) (-4.750 9.813)) 0 0 0 nil nil)
schCreateWireLabel(cv nil '(-4.250 9.813) "IBOTA2" "lowerRight" "R0" "stick" 0.0625 nil)
schCreatePin(cv nil "IBOTA2" "inputOutput" nil '(-4.750 9.813) "R0")
schCreateWire(cv "route" "full" '((-3.125 9.875) (-2.375 9.875)) 0 0 0 nil nil)
schCreateWireLabel(cv nil '(-2.875 9.875) "AVSS2" "lowerLeft" "R0" "stick" 0.0625 nil)
schCreateWire(cv "route" "full" '((-3.125 9.500) (-2.375 9.500)) 0 0 0 nil nil)
schCreateWireLabel(cv nil '(-2.875 9.500) "GIOL" "lowerLeft" "R0" "stick" 0.0625 nil)
schCreateWire(cv "route" "full" '((-3.125 10.250) (-2.375 10.250)) 0 0 0 nil nil)
schCreateWireLabel(cv nil '(-2.875 10.250) "AVDDH2" "lowerLeft" "R0" "stick" 0.0625 nil)
dbCreateInst(cv pdb3ac_h_gMaster "VREFPF0_left89" '(-4.0 7.625) "R270")
schCreateWire(cv "route" "full" '((-4.000 7.813) (-4.750 7.813)) 0 0 0 nil nil)
schCreateWireLabel(cv nil '(-4.250 7.813) "VREFPF0" "lowerRight" "R0" "stick" 0.0625 nil)
schCreatePin(cv nil "VREFPF0" "inputOutput" nil '(-4.750 7.813) "R0")
schCreateWire(cv "route" "full" '((-3.125 7.875) (-2.375 7.875)) 0 0 0 nil nil)
schCreateWireLabel(cv nil '(-2.875 7.875) "AVSS2" "lowerLeft" "R0" "stick" 0.0625 nil)
schCreateWire(cv "route" "full" '((-3.125 7.500) (-2.375 7.500)) 0 0 0 nil nil)
schCreateWireLabel(cv nil '(-2.875 7.500) "GIOL" "lowerLeft" "R0" "stick" 0.0625 nil)
schCreateWire(cv "route" "full" '((-3.125 8.250) (-2.375 8.250)) 0 0 0 nil nil)
schCreateWireLabel(cv nil '(-2.875 8.250) "AVDDH2" "lowerLeft" "R0" "stick" 0.0625 nil)
dbCreateInst(cv pdb3ac_h_gMaster "IBOTA0_left910" '(-4.0 5.625) "R270")
schCreateWire(cv "route" "full" '((-4.000 5.813) (-4.750 5.813)) 0 0 0 nil nil)
schCreateWireLabel(cv nil '(-4.250 5.813) "IBOTA0" "lowerRight" "R0" "stick" 0.0625 nil)
schCreatePin(cv nil "IBOTA0" "inputOutput" nil '(-4.750 5.813) "R0")
schCreateWire(cv "route" "full" '((-3.125 5.875) (-2.375 5.875)) 0 0 0 nil nil)
schCreateWireLabel(cv nil '(-2.875 5.875) "AVSS2" "lowerLeft" "R0" "stick" 0.0625 nil)
schCreateWire(cv "route" "full" '((-3.125 5.500) (-2.375 5.500)) 0 0 0 nil nil)
schCreateWireLabel(cv nil '(-2.875 5.500) "GIOL" "lowerLeft" "R0" "stick" 0.0625 nil)
schCreateWire(cv "route" "full" '((-3.125 6.250) (-2.375 6.250)) 0 0 0 nil nil)
schCreateWireLabel(cv nil '(-2.875 6.250) "AVDDH2" "lowerLeft" "R0" "stick" 0.0625 nil)
dbCreateInst(cv pdb3ac_h_gMaster "VREFNF0_left1011" '(-4.0 3.625) "R270")
schCreateWire(cv "route" "full" '((-4.000 3.813) (-4.750 3.813)) 0 0 0 nil nil)
schCreateWireLabel(cv nil '(-4.250 3.813) "VREFNF0" "lowerRight" "R0" "stick" 0.0625 nil)
schCreatePin(cv nil "VREFNF0" "inputOutput" nil '(-4.750 3.813) "R0")
schCreateWire(cv "route" "full" '((-3.125 3.875) (-2.375 3.875)) 0 0 0 nil nil)
schCreateWireLabel(cv nil '(-2.875 3.875) "AVSS2" "lowerLeft" "R0" "stick" 0.0625 nil)
schCreateWire(cv "route" "full" '((-3.125 3.500) (-2.375 3.500)) 0 0 0 nil nil)
schCreateWireLabel(cv nil '(-2.875 3.500) "GIOL" "lowerLeft" "R0" "stick" 0.0625 nil)
schCreateWire(cv "route" "full" '((-3.125 4.250) (-2.375 4.250)) 0 0 0 nil nil)
schCreateWireLabel(cv nil '(-2.875 4.250) "AVDDH2" "lowerLeft" "R0" "stick" 0.0625 nil)
dbCreateInst(cv pdb3ac_h_gMaster "VREFNF2_right45" '(60.0 12.375) "R90")
schCreateWire(cv "route" "full" '((60.000 12.187) (60.750 12.187)) 0 0 0 nil nil)
schCreateWireLabel(cv nil '(60.250 12.187) "VREFNF2" "lowerLeft" "R0" "stick" 0.0625 nil)
schCreatePin(cv nil "VREFNF2" "inputOutput" nil '(60.750 12.187) "R180")
schCreateWire(cv "route" "full" '((59.125 12.125) (58.375 12.125)) 0 0 0 nil nil)
schCreateWireLabel(cv nil '(58.875 12.125) "AVSS3" "lowerRight" "R0" "stick" 0.0625 nil)
schCreateWire(cv "route" "full" '((59.125 12.500) (58.375 12.500)) 0 0 0 nil nil)
schCreateWireLabel(cv nil '(58.875 12.500) "GIOL" "lowerRight" "R0" "stick" 0.0625 nil)
schCreateWire(cv "route" "full" '((59.125 11.750) (58.375 11.750)) 0 0 0 nil nil)
schCreateWireLabel(cv nil '(58.875 11.750) "AVDDH3" "lowerRight" "R0" "stick" 0.0625 nil)
dbCreateInst(cv pdb3ac_h_gMaster "VREFN2_right56" '(60.0 14.375) "R90")
schCreateWire(cv "route" "full" '((60.000 14.187) (60.750 14.187)) 0 0 0 nil nil)
schCreateWireLabel(cv nil '(60.250 14.187) "VREFN2" "lowerLeft" "R0" "stick" 0.0625 nil)
schCreatePin(cv nil "VREFN2" "inputOutput" nil '(60.750 14.187) "R180")
schCreateWire(cv "route" "full" '((59.125 14.125) (58.375 14.125)) 0 0 0 nil nil)
schCreateWireLabel(cv nil '(58.875 14.125) "AVSS3" "lowerRight" "R0" "stick" 0.0625 nil)
schCreateWire(cv "route" "full" '((59.125 14.500) (58.375 14.500)) 0 0 0 nil nil)
schCreateWireLabel(cv nil '(58.875 14.500) "GIOL" "lowerRight" "R0" "stick" 0.0625 nil)
schCreateWire(cv "route" "full" '((59.125 13.750) (58.375 13.750)) 0 0 0 nil nil)
schCreateWireLabel(cv nil '(58.875 13.750) "AVDDH3" "lowerRight" "R0" "stick" 0.0625 nil)
dbCreateInst(cv pdb3ac_h_gMaster "VREFNF3_right67" '(60.0 16.375) "R90")
schCreateWire(cv "route" "full" '((60.000 16.187) (60.750 16.187)) 0 0 0 nil nil)
schCreateWireLabel(cv nil '(60.250 16.187) "VREFNF3" "lowerLeft" "R0" "stick" 0.0625 nil)
schCreatePin(cv nil "VREFNF3" "inputOutput" nil '(60.750 16.187) "R180")
schCreateWire(cv "route" "full" '((59.125 16.125) (58.375 16.125)) 0 0 0 nil nil)
schCreateWireLabel(cv nil '(58.875 16.125) "AVSS3" "lowerRight" "R0" "stick" 0.0625 nil)
schCreateWire(cv "route" "full" '((59.125 16.500) (58.375 16.500)) 0 0 0 nil nil)
schCreateWireLabel(cv nil '(58.875 16.500) "GIOL" "lowerRight" "R0" "stick" 0.0625 nil)
schCreateWire(cv "route" "full" '((59.125 15.750) (58.375 15.750)) 0 0 0 nil nil)
schCreateWireLabel(cv nil '(58.875 15.750) "AVDDH3" "lowerRight" "R0" "stick" 0.0625 nil)
dbCreateInst(cv pdb3ac_h_gMaster "VREFN3_right78" '(60.0 18.375) "R90")
schCreateWire(cv "route" "full" '((60.000 18.187) (60.750 18.187)) 0 0 0 nil nil)
schCreateWireLabel(cv nil '(60.250 18.187) "VREFN3" "lowerLeft" "R0" "stick" 0.0625 nil)
schCreatePin(cv nil "VREFN3" "inputOutput" nil '(60.750 18.187) "R180")
schCreateWire(cv "route" "full" '((59.125 18.125) (58.375 18.125)) 0 0 0 nil nil)
schCreateWireLabel(cv nil '(58.875 18.125) "AVSS3" "lowerRight" "R0" "stick" 0.0625 nil)
schCreateWire(cv "route" "full" '((59.125 18.500) (58.375 18.500)) 0 0 0 nil nil)
schCreateWireLabel(cv nil '(58.875 18.500) "GIOL" "lowerRight" "R0" "stick" 0.0625 nil)
schCreateWire(cv "route" "full" '((59.125 17.750) (58.375 17.750)) 0 0 0 nil nil)
schCreateWireLabel(cv nil '(58.875 17.750) "AVDDH3" "lowerRight" "R0" "stick" 0.0625 nil)
dbCreateInst(cv pdb3ac_h_gMaster "VREFPF4_left01" '(-4.0 23.625) "R270")
schCreateWire(cv "route" "full" '((-4.000 23.813) (-4.750 23.813)) 0 0 0 nil nil)
schCreateWireLabel(cv nil '(-4.250 23.813) "VREFPF4" "lowerRight" "R0" "stick" 0.0625 nil)
schCreatePin(cv nil "VREFPF4" "inputOutput" nil '(-4.750 23.813) "R0")
schCreateWire(cv "route" "full" '((-3.125 23.875) (-2.375 23.875)) 0 0 0 nil nil)
schCreateWireLabel(cv nil '(-2.875 23.875) "AVSS2" "lowerLeft" "R0" "stick" 0.0625 nil)
schCreateWire(cv "route" "full" '((-3.125 23.500) (-2.375 23.500)) 0 0 0 nil nil)
schCreateWireLabel(cv nil '(-2.875 23.500) "GIOL" "lowerLeft" "R0" "stick" 0.0625 nil)
schCreateWire(cv "route" "full" '((-3.125 24.250) (-2.375 24.250)) 0 0 0 nil nil)
schCreateWireLabel(cv nil '(-2.875 24.250) "AVDDH2" "lowerLeft" "R0" "stick" 0.0625 nil)
dbCreateInst(cv pdb3ac_h_gMaster "VREFNF4_left12" '(-4.0 21.625) "R270")
schCreateWire(cv "route" "full" '((-4.000 21.813) (-4.750 21.813)) 0 0 0 nil nil)
schCreateWireLabel(cv nil '(-4.250 21.813) "VREFNF4" "lowerRight" "R0" "stick" 0.0625 nil)
schCreatePin(cv nil "VREFNF4" "inputOutput" nil '(-4.750 21.813) "R0")
schCreateWire(cv "route" "full" '((-3.125 21.875) (-2.375 21.875)) 0 0 0 nil nil)
schCreateWireLabel(cv nil '(-2.875 21.875) "AVSS2" "lowerLeft" "R0" "stick" 0.0625 nil)
schCreateWire(cv "route" "full" '((-3.125 21.500) (-2.375 21.500)) 0 0 0 nil nil)
schCreateWireLabel(cv nil '(-2.875 21.500) "GIOL" "lowerLeft" "R0" "stick" 0.0625 nil)
schCreateWire(cv "route" "full" '((-3.125 22.250) (-2.375 22.250)) 0 0 0 nil nil)
schCreateWireLabel(cv nil '(-2.875 22.250) "AVDDH2" "lowerLeft" "R0" "stick" 0.0625 nil)
pvdd1dgz_v_gMaster = dbOpenCellView("tphn28hpcpgv18" "PVDD1DGZ_V_G" "symbol")
dbCreateInst(cv pvdd1dgz_v_gMaster "VIOL_top89" '(38.0 32.0) "R180")
schCreateWire(cv "route" "full" '((37.625 31.000) (37.625 30.250)) 0 0 0 nil nil)
schCreateWireLabel(cv nil '(37.625 30.750) "POC" "lowerRight" "R90" "stick" 0.0625 nil)
schCreateWire(cv "route" "full" '((37.000 32.000) (37.000 32.750)) 0 0 0 nil nil)
schCreateWireLabel(cv nil '(37.000 32.250) "VIOL" "lowerLeft" "R90" "stick" 0.0625 nil)
schCreatePin(cv nil "VIOL" "inputOutput" nil '(37.000 32.750) "R270")
schCreateWire(cv "route" "full" '((37.250 31.000) (37.250 30.250)) 0 0 0 nil nil)
schCreateWireLabel(cv nil '(37.250 30.750) "GIOL" "lowerRight" "R90" "stick" 0.0625 nil)
schCreateWire(cv "route" "full" '((37.062 31.000) (37.062 30.250)) 0 0 0 nil nil)
schCreateWireLabel(cv nil '(37.062 30.750) "VIOH" "lowerRight" "R90" "stick" 0.0625 nil)
schCreateWire(cv "route" "full" '((36.688 31.000) (36.688 30.250)) 0 0 0 nil nil)
schCreateWireLabel(cv nil '(36.688 30.750) "GIOH" "lowerRight" "R90" "stick" 0.0625 nil)
pvss2dgz_v_gMaster = dbOpenCellView("tphn28hpcpgv18" "PVSS2DGZ_V_G" "symbol")
dbCreateInst(cv pvss2dgz_v_gMaster "GIOH_top910" '(35.84375 32.0) "R180")
schCreateWire(cv "route" "full" '((35.469 31.000) (35.469 30.250)) 0 0 0 nil nil)
schCreateWireLabel(cv nil '(35.469 30.750) "POC" "lowerRight" "R90" "stick" 0.0625 nil)
schCreateWire(cv "route" "full" '((35.282 31.000) (35.282 30.250)) 0 0 0 nil nil)
schCreateWireLabel(cv nil '(35.282 30.750) "VIOL" "lowerRight" "R90" "stick" 0.0625 nil)
schCreateWire(cv "route" "full" '((35.094 31.000) (35.094 30.250)) 0 0 0 nil nil)
schCreateWireLabel(cv nil '(35.094 30.750) "GIOL" "lowerRight" "R90" "stick" 0.0625 nil)
schCreateWire(cv "route" "full" '((34.906 31.000) (34.906 30.250)) 0 0 0 nil nil)
schCreateWireLabel(cv nil '(34.906 30.750) "VIOH" "lowerRight" "R90" "stick" 0.0625 nil)
schCreateWire(cv "route" "full" '((34.844 32.000) (34.844 32.750)) 0 0 0 nil nil)
schCreateWireLabel(cv nil '(34.844 32.250) "GIOH" "lowerLeft" "R90" "stick" 0.0625 nil)
schCreatePin(cv nil "GIOH" "inputOutput" nil '(34.844 32.750) "R270")
dbCreateInst(cv pddw16sdgz_v_gMaster "SEL_0_top1011" '(33.375 32.0) "R180")
schCreateWire(cv "route" "full" '((33.250 31.000) (33.250 30.250)) 0 0 0 nil nil)
schCreateWireLabel(cv nil '(33.250 30.750) "GIOL" "lowerRight" "R90" "stick" 0.0625 nil)
schCreateWire(cv "route" "full" '((33.125 31.000) (33.125 30.250)) 0 0 0 nil nil)
schCreateWireLabel(cv nil '(33.125 30.750) "SEL_CORE<0>" "lowerRight" "R90" "stick" 0.0625 nil)
schCreatePin(cv nil "SEL_CORE<0>" "inputOutput" nil '(33.125 30.250) "R90")
schCreateWire(cv "route" "full" '((33.500 31.000) (33.500 30.250)) 0 0 0 nil nil)
schCreateWireLabel(cv nil '(33.500 30.750) "VIOL" "lowerRight" "R90" "stick" 0.0625 nil)
schCreateWire(cv "route" "full" '((33.625 31.000) (33.625 30.250)) 0 0 0 nil nil)
schCreateWireLabel(cv nil '(33.625 30.750) "GIOL" "lowerRight" "R90" "stick" 0.0625 nil)
schCreateWire(cv "route" "full" '((32.687 32.000) (32.687 32.750)) 0 0 0 nil nil)
schCreateWireLabel(cv nil '(32.687 32.250) "SEL<0>" "lowerLeft" "R90" "stick" 0.0625 nil)
schCreatePin(cv nil "SEL<0>" "inputOutput" nil '(32.687 32.750) "R270")
schCreateWire(cv "route" "full" '((33.000 31.000) (33.000 30.250)) 0 0 0 nil nil)
schCreateWireLabel(cv nil '(33.000 30.750) "POC" "lowerRight" "R90" "stick" 0.0625 nil)
schCreateWire(cv "route" "full" '((32.813 31.000) (32.813 30.250)) 0 0 0 nil nil)
schCreateWireLabel(cv nil '(32.813 30.750) "VIOL" "lowerRight" "R90" "stick" 0.0625 nil)
schCreateWire(cv "route" "full" '((32.625 31.000) (32.625 30.250)) 0 0 0 nil nil)
schCreateWireLabel(cv nil '(32.625 30.750) "GIOL" "lowerRight" "R90" "stick" 0.0625 nil)
schCreateWire(cv "route" "full" '((32.437 31.000) (32.437 30.250)) 0 0 0 nil nil)
schCreateWireLabel(cv nil '(32.437 30.750) "VIOH" "lowerRight" "R90" "stick" 0.0625 nil)
schCreateWire(cv "route" "full" '((32.063 31.000) (32.063 30.250)) 0 0 0 nil nil)
schCreateWireLabel(cv nil '(32.063 30.750) "GIOH" "lowerRight" "R90" "stick" 0.0625 nil)
dbCreateInst(cv pddw16sdgz_v_gMaster "SEL_2_top1112" '(31.375 32.0) "R180")
schCreateWire(cv "route" "full" '((31.250 31.000) (31.250 30.250)) 0 0 0 nil nil)
schCreateWireLabel(cv nil '(31.250 30.750) "GIOL" "lowerRight" "R90" "stick" 0.0625 nil)
schCreateWire(cv "route" "full" '((31.125 31.000) (31.125 30.250)) 0 0 0 nil nil)
schCreateWireLabel(cv nil '(31.125 30.750) "SEL_CORE<2>" "lowerRight" "R90" "stick" 0.0625 nil)
schCreatePin(cv nil "SEL_CORE<2>" "inputOutput" nil '(31.125 30.250) "R90")
schCreateWire(cv "route" "full" '((31.500 31.000) (31.500 30.250)) 0 0 0 nil nil)
schCreateWireLabel(cv nil '(31.500 30.750) "VIOL" "lowerRight" "R90" "stick" 0.0625 nil)
schCreateWire(cv "route" "full" '((31.625 31.000) (31.625 30.250)) 0 0 0 nil nil)
schCreateWireLabel(cv nil '(31.625 30.750) "GIOL" "lowerRight" "R90" "stick" 0.0625 nil)
schCreateWire(cv "route" "full" '((30.687 32.000) (30.687 32.750)) 0 0 0 nil nil)
schCreateWireLabel(cv nil '(30.687 32.250) "SEL<2>" "lowerLeft" "R90" "stick" 0.0625 nil)
schCreatePin(cv nil "SEL<2>" "inputOutput" nil '(30.687 32.750) "R270")
schCreateWire(cv "route" "full" '((31.000 31.000) (31.000 30.250)) 0 0 0 nil nil)
schCreateWireLabel(cv nil '(31.000 30.750) "POC" "lowerRight" "R90" "stick" 0.0625 nil)
schCreateWire(cv "route" "full" '((30.813 31.000) (30.813 30.250)) 0 0 0 nil nil)
schCreateWireLabel(cv nil '(30.813 30.750) "VIOL" "lowerRight" "R90" "stick" 0.0625 nil)
schCreateWire(cv "route" "full" '((30.625 31.000) (30.625 30.250)) 0 0 0 nil nil)
schCreateWireLabel(cv nil '(30.625 30.750) "GIOL" "lowerRight" "R90" "stick" 0.0625 nil)
schCreateWire(cv "route" "full" '((30.437 31.000) (30.437 30.250)) 0 0 0 nil nil)
schCreateWireLabel(cv nil '(30.437 30.750) "VIOH" "lowerRight" "R90" "stick" 0.0625 nil)
schCreateWire(cv "route" "full" '((30.063 31.000) (30.063 30.250)) 0 0 0 nil nil)
schCreateWireLabel(cv nil '(30.063 30.750) "GIOH" "lowerRight" "R90" "stick" 0.0625 nil)
dbCreateInst(cv pddw16sdgz_v_gMaster "SDO_top1213" '(29.375 32.0) "R180")
schCreateWire(cv "route" "full" '((29.250 31.000) (29.250 30.250)) 0 0 0 nil nil)
schCreateWireLabel(cv nil '(29.250 30.750) "VIOL" "lowerRight" "R90" "stick" 0.0625 nil)
schCreateWire(cv "route" "full" '((29.125 31.000) (29.125 30.250)) 0 0 0 nil nil)
dbCreateInst(cv noConnMaster "noConn_SDO_top1213_C" '(29.125 30.250) "R0")
schCreateWire(cv "route" "full" '((29.500 31.000) (29.500 30.250)) 0 0 0 nil nil)
schCreateWireLabel(cv nil '(29.500 30.750) "GIOL" "lowerRight" "R90" "stick" 0.0625 nil)
schCreateWire(cv "route" "full" '((29.625 31.000) (29.625 30.250)) 0 0 0 nil nil)
schCreateWireLabel(cv nil '(29.625 30.750) "SDO_CORE" "lowerRight" "R90" "stick" 0.0625 nil)
schCreatePin(cv nil "SDO_CORE" "inputOutput" nil '(29.625 30.250) "R90")
schCreateWire(cv "route" "full" '((28.687 32.000) (28.687 32.750)) 0 0 0 nil nil)
schCreateWireLabel(cv nil '(28.687 32.250) "SDO" "lowerLeft" "R90" "stick" 0.0625 nil)
schCreatePin(cv nil "SDO" "inputOutput" nil '(28.687 32.750) "R270")
schCreateWire(cv "route" "full" '((29.000 31.000) (29.000 30.250)) 0 0 0 nil nil)
schCreateWireLabel(cv nil '(29.000 30.750) "POC" "lowerRight" "R90" "stick" 0.0625 nil)
schCreateWire(cv "route" "full" '((28.813 31.000) (28.813 30.250)) 0 0 0 nil nil)
schCreateWireLabel(cv nil '(28.813 30.750) "VIOL" "lowerRight" "R90" "stick" 0.0625 nil)
schCreateWire(cv "route" "full" '((28.625 31.000) (28.625 30.250)) 0 0 0 nil nil)
schCreateWireLabel(cv nil '(28.625 30.750) "GIOL" "lowerRight" "R90" "stick" 0.0625 nil)
schCreateWire(cv "route" "full" '((28.437 31.000) (28.437 30.250)) 0 0 0 nil nil)
schCreateWireLabel(cv nil '(28.437 30.750) "VIOH" "lowerRight" "R90" "stick" 0.0625 nil)
schCreateWire(cv "route" "full" '((28.063 31.000) (28.063 30.250)) 0 0 0 nil nil)
schCreateWireLabel(cv nil '(28.063 30.750) "GIOH" "lowerRight" "R90" "stick" 0.0625 nil)
dbCreateInst(cv pddw16sdgz_v_gMaster "D_0_top1314" '(27.375 32.0) "R180")
schCreateWire(cv "route" "full" '((27.250 31.000) (27.250 30.250)) 0 0 0 nil nil)
schCreateWireLabel(cv nil '(27.250 30.750) "VIOL" "lowerRight" "R90" "stick" 0.0625 nil)
schCreateWire(cv "route" "full" '((27.125 31.000) (27.125 30.250)) 0 0 0 nil nil)
dbCreateInst(cv noConnMaster "noConn_D_0_top1314_C" '(27.125 30.250) "R0")
schCreateWire(cv "route" "full" '((27.500 31.000) (27.500 30.250)) 0 0 0 nil nil)
schCreateWireLabel(cv nil '(27.500 30.750) "GIOL" "lowerRight" "R90" "stick" 0.0625 nil)
schCreateWire(cv "route" "full" '((27.625 31.000) (27.625 30.250)) 0 0 0 nil nil)
schCreateWireLabel(cv nil '(27.625 30.750) "D_CORE<0>" "lowerRight" "R90" "stick" 0.0625 nil)
schCreatePin(cv nil "D_CORE<0>" "inputOutput" nil '(27.625 30.250) "R90")
schCreateWire(cv "route" "full" '((26.687 32.000) (26.687 32.750)) 0 0 0 nil nil)
schCreateWireLabel(cv nil '(26.687 32.250) "D<0>" "lowerLeft" "R90" "stick" 0.0625 nil)
schCreatePin(cv nil "D<0>" "inputOutput" nil '(26.687 32.750) "R270")
schCreateWire(cv "route" "full" '((27.000 31.000) (27.000 30.250)) 0 0 0 nil nil)
schCreateWireLabel(cv nil '(27.000 30.750) "POC" "lowerRight" "R90" "stick" 0.0625 nil)
schCreateWire(cv "route" "full" '((26.813 31.000) (26.813 30.250)) 0 0 0 nil nil)
schCreateWireLabel(cv nil '(26.813 30.750) "VIOL" "lowerRight" "R90" "stick" 0.0625 nil)
schCreateWire(cv "route" "full" '((26.625 31.000) (26.625 30.250)) 0 0 0 nil nil)
schCreateWireLabel(cv nil '(26.625 30.750) "GIOL" "lowerRight" "R90" "stick" 0.0625 nil)
schCreateWire(cv "route" "full" '((26.437 31.000) (26.437 30.250)) 0 0 0 nil nil)
schCreateWireLabel(cv nil '(26.437 30.750) "VIOH" "lowerRight" "R90" "stick" 0.0625 nil)
schCreateWire(cv "route" "full" '((26.063 31.000) (26.063 30.250)) 0 0 0 nil nil)
schCreateWireLabel(cv nil '(26.063 30.750) "GIOH" "lowerRight" "R90" "stick" 0.0625 nil)
dbCreateInst(cv pddw16sdgz_v_gMaster "D_2_top1415" '(25.375 32.0) "R180")
schCreateWire(cv "route" "full" '((25.250 31.000) (25.250 30.250)) 0 0 0 nil nil)
schCreateWireLabel(cv nil '(25.250 30.750) "VIOL" "lowerRight" "R90" "stick" 0.0625 nil)
schCreateWire(cv "route" "full" '((25.125 31.000) (25.125 30.250)) 0 0 0 nil nil)
dbCreateInst(cv noConnMaster "noConn_D_2_top1415_C" '(25.125 30.250) "R0")
schCreateWire(cv "route" "full" '((25.500 31.000) (25.500 30.250)) 0 0 0 nil nil)
schCreateWireLabel(cv nil '(25.500 30.750) "GIOL" "lowerRight" "R90" "stick" 0.0625 nil)
schCreateWire(cv "route" "full" '((25.625 31.000) (25.625 30.250)) 0 0 0 nil nil)
schCreateWireLabel(cv nil '(25.625 30.750) "D_CORE<2>" "lowerRight" "R90" "stick" 0.0625 nil)
schCreatePin(cv nil "D_CORE<2>" "inputOutput" nil '(25.625 30.250) "R90")
schCreateWire(cv "route" "full" '((24.687 32.000) (24.687 32.750)) 0 0 0 nil nil)
schCreateWireLabel(cv nil '(24.687 32.250) "D<2>" "lowerLeft" "R90" "stick" 0.0625 nil)
schCreatePin(cv nil "D<2>" "inputOutput" nil '(24.687 32.750) "R270")
schCreateWire(cv "route" "full" '((25.000 31.000) (25.000 30.250)) 0 0 0 nil nil)
schCreateWireLabel(cv nil '(25.000 30.750) "POC" "lowerRight" "R90" "stick" 0.0625 nil)
schCreateWire(cv "route" "full" '((24.813 31.000) (24.813 30.250)) 0 0 0 nil nil)
schCreateWireLabel(cv nil '(24.813 30.750) "VIOL" "lowerRight" "R90" "stick" 0.0625 nil)
schCreateWire(cv "route" "full" '((24.625 31.000) (24.625 30.250)) 0 0 0 nil nil)
schCreateWireLabel(cv nil '(24.625 30.750) "GIOL" "lowerRight" "R90" "stick" 0.0625 nil)
schCreateWire(cv "route" "full" '((24.437 31.000) (24.437 30.250)) 0 0 0 nil nil)
schCreateWireLabel(cv nil '(24.437 30.750) "VIOH" "lowerRight" "R90" "stick" 0.0625 nil)
schCreateWire(cv "route" "full" '((24.063 31.000) (24.063 30.250)) 0 0 0 nil nil)
schCreateWireLabel(cv nil '(24.063 30.750) "GIOH" "lowerRight" "R90" "stick" 0.0625 nil)
dbCreateInst(cv pddw16sdgz_v_gMaster "D_4_top1516" '(23.375 32.0) "R180")
schCreateWire(cv "route" "full" '((23.250 31.000) (23.250 30.250)) 0 0 0 nil nil)
schCreateWireLabel(cv nil '(23.250 30.750) "VIOL" "lowerRight" "R90" "stick" 0.0625 nil)
schCreateWire(cv "route" "full" '((23.125 31.000) (23.125 30.250)) 0 0 0 nil nil)
dbCreateInst(cv noConnMaster "noConn_D_4_top1516_C" '(23.125 30.250) "R0")
schCreateWire(cv "route" "full" '((23.500 31.000) (23.500 30.250)) 0 0 0 nil nil)
schCreateWireLabel(cv nil '(23.500 30.750) "GIOL" "lowerRight" "R90" "stick" 0.0625 nil)
schCreateWire(cv "route" "full" '((23.625 31.000) (23.625 30.250)) 0 0 0 nil nil)
schCreateWireLabel(cv nil '(23.625 30.750) "D_CORE<4>" "lowerRight" "R90" "stick" 0.0625 nil)
schCreatePin(cv nil "D_CORE<4>" "inputOutput" nil '(23.625 30.250) "R90")
schCreateWire(cv "route" "full" '((22.687 32.000) (22.687 32.750)) 0 0 0 nil nil)
schCreateWireLabel(cv nil '(22.687 32.250) "D<4>" "lowerLeft" "R90" "stick" 0.0625 nil)
schCreatePin(cv nil "D<4>" "inputOutput" nil '(22.687 32.750) "R270")
schCreateWire(cv "route" "full" '((23.000 31.000) (23.000 30.250)) 0 0 0 nil nil)
schCreateWireLabel(cv nil '(23.000 30.750) "POC" "lowerRight" "R90" "stick" 0.0625 nil)
schCreateWire(cv "route" "full" '((22.813 31.000) (22.813 30.250)) 0 0 0 nil nil)
schCreateWireLabel(cv nil '(22.813 30.750) "VIOL" "lowerRight" "R90" "stick" 0.0625 nil)
schCreateWire(cv "route" "full" '((22.625 31.000) (22.625 30.250)) 0 0 0 nil nil)
schCreateWireLabel(cv nil '(22.625 30.750) "GIOL" "lowerRight" "R90" "stick" 0.0625 nil)
schCreateWire(cv "route" "full" '((22.437 31.000) (22.437 30.250)) 0 0 0 nil nil)
schCreateWireLabel(cv nil '(22.437 30.750) "VIOH" "lowerRight" "R90" "stick" 0.0625 nil)
schCreateWire(cv "route" "full" '((22.063 31.000) (22.063 30.250)) 0 0 0 nil nil)
schCreateWireLabel(cv nil '(22.063 30.750) "GIOH" "lowerRight" "R90" "stick" 0.0625 nil)
dbCreateInst(cv pddw16sdgz_v_gMaster "RST_top1617" '(21.375 32.0) "R180")
schCreateWire(cv "route" "full" '((21.250 31.000) (21.250 30.250)) 0 0 0 nil nil)
schCreateWireLabel(cv nil '(21.250 30.750) "GIOL" "lowerRight" "R90" "stick" 0.0625 nil)
schCreateWire(cv "route" "full" '((21.125 31.000) (21.125 30.250)) 0 0 0 nil nil)
schCreateWireLabel(cv nil '(21.125 30.750) "RST_CORE" "lowerRight" "R90" "stick" 0.0625 nil)
schCreatePin(cv nil "RST_CORE" "inputOutput" nil '(21.125 30.250) "R90")
schCreateWire(cv "route" "full" '((21.500 31.000) (21.500 30.250)) 0 0 0 nil nil)
schCreateWireLabel(cv nil '(21.500 30.750) "VIOL" "lowerRight" "R90" "stick" 0.0625 nil)
schCreateWire(cv "route" "full" '((21.625 31.000) (21.625 30.250)) 0 0 0 nil nil)
schCreateWireLabel(cv nil '(21.625 30.750) "GIOL" "lowerRight" "R90" "stick" 0.0625 nil)
schCreateWire(cv "route" "full" '((20.687 32.000) (20.687 32.750)) 0 0 0 nil nil)
schCreateWireLabel(cv nil '(20.687 32.250) "RST" "lowerLeft" "R90" "stick" 0.0625 nil)
schCreatePin(cv nil "RST" "inputOutput" nil '(20.687 32.750) "R270")
schCreateWire(cv "route" "full" '((21.000 31.000) (21.000 30.250)) 0 0 0 nil nil)
schCreateWireLabel(cv nil '(21.000 30.750) "POC" "lowerRight" "R90" "stick" 0.0625 nil)
schCreateWire(cv "route" "full" '((20.813 31.000) (20.813 30.250)) 0 0 0 nil nil)
schCreateWireLabel(cv nil '(20.813 30.750) "VIOL" "lowerRight" "R90" "stick" 0.0625 nil)
schCreateWire(cv "route" "full" '((20.625 31.000) (20.625 30.250)) 0 0 0 nil nil)
schCreateWireLabel(cv nil '(20.625 30.750) "GIOL" "lowerRight" "R90" "stick" 0.0625 nil)
schCreateWire(cv "route" "full" '((20.437 31.000) (20.437 30.250)) 0 0 0 nil nil)
schCreateWireLabel(cv nil '(20.437 30.750) "VIOH" "lowerRight" "R90" "stick" 0.0625 nil)
schCreateWire(cv "route" "full" '((20.063 31.000) (20.063 30.250)) 0 0 0 nil nil)
schCreateWireLabel(cv nil '(20.063 30.750) "GIOH" "lowerRight" "R90" "stick" 0.0625 nil)
dbCreateInst(cv pdb3ac_v_gMaster "VREFPF4_top2021" '(11.625 32.0) "R180")
schCreateWire(cv "route" "full" '((11.813 32.000) (11.813 32.750)) 0 0 0 nil nil)
schCreateWireLabel(cv nil '(11.813 32.250) "VREFPF4" "lowerLeft" "R90" "stick" 0.0625 nil)
schCreatePin(cv nil "VREFPF4" "inputOutput" nil '(11.813 32.750) "R270")
schCreateWire(cv "route" "full" '((11.875 31.125) (11.875 30.375)) 0 0 0 nil nil)
schCreateWireLabel(cv nil '(11.875 30.875) "AVSS2" "lowerRight" "R90" "stick" 0.0625 nil)
schCreateWire(cv "route" "full" '((11.500 31.125) (11.500 30.375)) 0 0 0 nil nil)
schCreateWireLabel(cv nil '(11.500 30.875) "GIOL" "lowerRight" "R90" "stick" 0.0625 nil)
schCreateWire(cv "route" "full" '((12.250 31.125) (12.250 30.375)) 0 0 0 nil nil)
schCreateWireLabel(cv nil '(12.250 30.875) "AVDDH2" "lowerRight" "R90" "stick" 0.0625 nil)
dbCreateInst(cv pdb3ac_v_gMaster "VCM_top2122" '(9.625 32.0) "R180")
schCreateWire(cv "route" "full" '((9.813 32.000) (9.813 32.750)) 0 0 0 nil nil)
schCreateWireLabel(cv nil '(9.813 32.250) "VCM" "lowerLeft" "R90" "stick" 0.0625 nil)
schCreatePin(cv nil "VCM" "inputOutput" nil '(9.813 32.750) "R270")
schCreateWire(cv "route" "full" '((9.875 31.125) (9.875 30.375)) 0 0 0 nil nil)
schCreateWireLabel(cv nil '(9.875 30.875) "AVSS2" "lowerRight" "R90" "stick" 0.0625 nil)
schCreateWire(cv "route" "full" '((9.500 31.125) (9.500 30.375)) 0 0 0 nil nil)
schCreateWireLabel(cv nil '(9.500 30.875) "GIOL" "lowerRight" "R90" "stick" 0.0625 nil)
schCreateWire(cv "route" "full" '((10.250 31.125) (10.250 30.375)) 0 0 0 nil nil)
schCreateWireLabel(cv nil '(10.250 30.875) "AVDDH2" "lowerRight" "R90" "stick" 0.0625 nil)
dbCreateInst(cv pdb3ac_v_gMaster "VREFNF4_top2223" '(7.625 32.0) "R180")
schCreateWire(cv "route" "full" '((7.813 32.000) (7.813 32.750)) 0 0 0 nil nil)
schCreateWireLabel(cv nil '(7.813 32.250) "VREFNF4" "lowerLeft" "R90" "stick" 0.0625 nil)
schCreatePin(cv nil "VREFNF4" "inputOutput" nil '(7.813 32.750) "R270")
schCreateWire(cv "route" "full" '((7.875 31.125) (7.875 30.375)) 0 0 0 nil nil)
schCreateWireLabel(cv nil '(7.875 30.875) "AVSS2" "lowerRight" "R90" "stick" 0.0625 nil)
schCreateWire(cv "route" "full" '((7.500 31.125) (7.500 30.375)) 0 0 0 nil nil)
schCreateWireLabel(cv nil '(7.500 30.875) "GIOL" "lowerRight" "R90" "stick" 0.0625 nil)
schCreateWire(cv "route" "full" '((8.250 31.125) (8.250 30.375)) 0 0 0 nil nil)
schCreateWireLabel(cv nil '(8.250 30.875) "AVDDH2" "lowerRight" "R90" "stick" 0.0625 nil)
schCheck(cv)
dbSave(cv)
t
