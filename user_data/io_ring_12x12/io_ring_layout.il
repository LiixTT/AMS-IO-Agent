cv = geGetWindowCellView()
; Generated Layout Script with Dual Ring Support

; ==================== All Components (Sorted by Placement Order) ====================
dbCreateParamInstByMasterName(cv "tphn28hpcpgv18" "PDDW16SDGZ_V_G" "layout" "D4_top_0" list(150 940) "R180")
dbCreateParamInstByMasterName(cv "PAD" "PAD60GU" "layout" "pad60gu_D4_top_0" list(150 940) "R180")
dbCreateParamInstByMasterName(cv "tphn28hpcpgv18" "PDDW16SDGZ_V_G" "layout" "D3_top_1" list(210 940) "R180")
dbCreateParamInstByMasterName(cv "PAD" "PAD60GU" "layout" "pad60gu_D3_top_1" list(210 940) "R180")
dbCreateParamInstByMasterName(cv "tphn28hpcpgv18" "PDDW16SDGZ_V_G" "layout" "D2_top_2" list(270 940) "R180")
dbCreateParamInstByMasterName(cv "PAD" "PAD60GU" "layout" "pad60gu_D2_top_2" list(270 940) "R180")
dbCreateParamInstByMasterName(cv "tphn28hpcpgv18" "PDDW16SDGZ_V_G" "layout" "D1_top_3" list(330 940) "R180")
dbCreateParamInstByMasterName(cv "PAD" "PAD60GU" "layout" "pad60gu_D1_top_3" list(330 940) "R180")
dbCreateParamInstByMasterName(cv "tphn28hpcpgv18" "PDDW16SDGZ_V_G" "layout" "D0_top_4" list(390 940) "R180")
dbCreateParamInstByMasterName(cv "PAD" "PAD60GU" "layout" "pad60gu_D0_top_4" list(390 940) "R180")
dbCreateParamInstByMasterName(cv "tphn28hpcpgv18" "PDDW16SDGZ_V_G" "layout" "RST_top_5" list(450 940) "R180")
dbCreateParamInstByMasterName(cv "PAD" "PAD60GU" "layout" "pad60gu_RST_top_5" list(450 940) "R180")
dbCreateParamInstByMasterName(cv "tphn28hpcpgv18" "PDDW16SDGZ_V_G" "layout" "SDO_top_6" list(510 940) "R180")
dbCreateParamInstByMasterName(cv "PAD" "PAD60GU" "layout" "pad60gu_SDO_top_6" list(510 940) "R180")
dbCreateParamInstByMasterName(cv "tphn28hpcpgv18" "PDDW16SDGZ_V_G" "layout" "SCK_top_7" list(570 940) "R180")
dbCreateParamInstByMasterName(cv "PAD" "PAD60GU" "layout" "pad60gu_SCK_top_7" list(570 940) "R180")
dbCreateParamInstByMasterName(cv "tphn28hpcpgv18" "PDDW16SDGZ_V_G" "layout" "SDI_top_8" list(630 940) "R180")
dbCreateParamInstByMasterName(cv "PAD" "PAD60GU" "layout" "pad60gu_SDI_top_8" list(630 940) "R180")
dbCreateParamInstByMasterName(cv "tphn28hpcpgv18" "PDDW16SDGZ_V_G" "layout" "SLP_top_9" list(690 940) "R180")
dbCreateParamInstByMasterName(cv "PAD" "PAD60GU" "layout" "pad60gu_SLP_top_9" list(690 940) "R180")
dbCreateParamInstByMasterName(cv "tphn28hpcpgv18" "PDB3AC_V_G" "layout" "VREFDES2_top_10" list(750 940) "R180")
dbCreateParamInstByMasterName(cv "PAD" "PAD60GU" "layout" "pad60gu_VREFDES2_top_10" list(750 940) "R180")
dbCreateParamInstByMasterName(cv "tphn28hpcpgv18" "PDB3AC_V_G" "layout" "IBREF2_top_11" list(810 940) "R180")
dbCreateParamInstByMasterName(cv "PAD" "PAD60GU" "layout" "pad60gu_IBREF2_top_11" list(810 940) "R180")
dbCreateParamInstByMasterName(cv "tphn28hpcpgv18" "PCORNERA_G" "layout" "CORNER_TOP_RIGHT_top_right" list(940 940) "R180")
dbCreateParamInstByMasterName(cv "tphn28hpcpgv18" "PVSS3A_H_G" "layout" "VREFN_right_0" list(940 790) "R90")
dbCreateParamInstByMasterName(cv "PAD" "PAD60GU" "layout" "pad60gu_VREFN_right_0" list(940 790) "R90")
dbCreateParamInstByMasterName(cv "tphn28hpcpgv18" "PDB3AC_H_G" "layout" "VREFM_right_1" list(940 730) "R90")
dbCreateParamInstByMasterName(cv "PAD" "PAD60GU" "layout" "pad60gu_VREFM_right_1" list(940 730) "R90")
dbCreateParamInstByMasterName(cv "tphn28hpcpgv18" "PVDD3A_H_G" "layout" "VREFH_right_2" list(940 670) "R90")
dbCreateParamInstByMasterName(cv "PAD" "PAD60GU" "layout" "pad60gu_VREFH_right_2" list(940 670) "R90")
dbCreateParamInstByMasterName(cv "tphn28hpcpgv18" "PVSS1AC_H_G" "layout" "VSSSAR_right_3" list(940 610) "R90")
dbCreateParamInstByMasterName(cv "PAD" "PAD60GU" "layout" "pad60gu_VSSSAR_right_3" list(940 610) "R90")
dbCreateParamInstByMasterName(cv "tphn28hpcpgv18" "PVDD1AC_H_G" "layout" "VDDSAR_right_4" list(940 550) "R90")
dbCreateParamInstByMasterName(cv "PAD" "PAD60GU" "layout" "pad60gu_VDDSAR_right_4" list(940 550) "R90")
dbCreateParamInstByMasterName(cv "tphn28hpcpgv18" "PVDD1AC_H_G" "layout" "VDDCLK_right_5" list(940 490) "R90")
dbCreateParamInstByMasterName(cv "PAD" "PAD60GU" "layout" "pad60gu_VDDCLK_right_5" list(940 490) "R90")
dbCreateParamInstByMasterName(cv "tphn28hpcpgv18" "PVSS1AC_H_G" "layout" "VSSCLK_right_6" list(940 430) "R90")
dbCreateParamInstByMasterName(cv "PAD" "PAD60GU" "layout" "pad60gu_VSSCLK_right_6" list(940 430) "R90")
dbCreateParamInstByMasterName(cv "tphn28hpcpgv18" "PDB3AC_H_G" "layout" "VCM_right_7" list(940 370) "R90")
dbCreateParamInstByMasterName(cv "PAD" "PAD60GU" "layout" "pad60gu_VCM_right_7" list(940 370) "R90")
dbCreateParamInstByMasterName(cv "tphn28hpcpgv18" "PVDD3A_H_G" "layout" "VDD_DAT_right_8" list(940 310) "R90")
dbCreateParamInstByMasterName(cv "PAD" "PAD60GU" "layout" "pad60gu_VDD_DAT_right_8" list(940 310) "R90")
dbCreateParamInstByMasterName(cv "tphn28hpcpgv18" "PVSS3A_H_G" "layout" "GND_DAT_right_9" list(940 250) "R90")
dbCreateParamInstByMasterName(cv "PAD" "PAD60GU" "layout" "pad60gu_GND_DAT_right_9" list(940 250) "R90")
dbCreateParamInstByMasterName(cv "tphn28hpcpgv18" "PDB3AC_H_G" "layout" "CLKN_right_10" list(940 190) "R90")
dbCreateParamInstByMasterName(cv "PAD" "PAD60GU" "layout" "pad60gu_CLKN_right_10" list(940 190) "R90")
dbCreateParamInstByMasterName(cv "tphn28hpcpgv18" "PDB3AC_H_G" "layout" "CLKP_right_11" list(940 130) "R90")
dbCreateParamInstByMasterName(cv "PAD" "PAD60GU" "layout" "pad60gu_CLKP_right_11" list(940 130) "R90")
dbCreateParamInstByMasterName(cv "tphn28hpcpgv18" "PCORNERA_G" "layout" "CORNER_BOTTOM_RIGHT_bottom_right" list(940 0) "R90")
dbCreateParamInstByMasterName(cv "tphn28hpcpgv18" "PVSS3A_V_G" "layout" "GND_CKB_bottom_0" list(790 0) "R0")
dbCreateParamInstByMasterName(cv "PAD" "PAD60GU" "layout" "pad60gu_GND_CKB_bottom_0" list(790 0) "R0")
dbCreateParamInstByMasterName(cv "tphn28hpcpgv18" "PVDD3A_V_G" "layout" "VDD_CKB_bottom_1" list(730 0) "R0")
dbCreateParamInstByMasterName(cv "PAD" "PAD60GU" "layout" "pad60gu_VDD_CKB_bottom_1" list(730 0) "R0")
dbCreateParamInstByMasterName(cv "tphn28hpcpgv18" "PDB3AC_V_G" "layout" "VINCM_bottom_2" list(670 0) "R0")
dbCreateParamInstByMasterName(cv "PAD" "PAD60GU" "layout" "pad60gu_VINCM_bottom_2" list(670 0) "R0")
dbCreateParamInstByMasterName(cv "tphn28hpcpgv18" "PVSS3A_V_G" "layout" "VSSIB_bottom_3" list(610 0) "R0")
dbCreateParamInstByMasterName(cv "PAD" "PAD60GU" "layout" "pad60gu_VSSIB_bottom_3" list(610 0) "R0")
dbCreateParamInstByMasterName(cv "tphn28hpcpgv18" "PDB3AC_V_G" "layout" "VINP_bottom_4" list(550 0) "R0")
dbCreateParamInstByMasterName(cv "PAD" "PAD60GU" "layout" "pad60gu_VINP_bottom_4" list(550 0) "R0")
dbCreateParamInstByMasterName(cv "tphn28hpcpgv18" "PDB3AC_V_G" "layout" "VINN_bottom_5" list(490 0) "R0")
dbCreateParamInstByMasterName(cv "PAD" "PAD60GU" "layout" "pad60gu_VINN_bottom_5" list(490 0) "R0")
dbCreateParamInstByMasterName(cv "tphn28hpcpgv18" "PVSS3A_V_G" "layout" "VSSIB_bottom_6" list(430 0) "R0")
dbCreateParamInstByMasterName(cv "PAD" "PAD60GU" "layout" "pad60gu_VSSIB_bottom_6" list(430 0) "R0")
dbCreateParamInstByMasterName(cv "tphn28hpcpgv18" "PVDD3A_V_G" "layout" "VDDIB_bottom_7" list(370 0) "R0")
dbCreateParamInstByMasterName(cv "PAD" "PAD60GU" "layout" "pad60gu_VDDIB_bottom_7" list(370 0) "R0")
dbCreateParamInstByMasterName(cv "tphn28hpcpgv18" "PVSS1AC_V_G" "layout" "VSS_bottom_8" list(310 0) "R0")
dbCreateParamInstByMasterName(cv "PAD" "PAD60GU" "layout" "pad60gu_VSS_bottom_8" list(310 0) "R0")
dbCreateParamInstByMasterName(cv "tphn28hpcpgv18" "PDB3AC_V_G" "layout" "IBUF_IBIAS_bottom_9" list(250 0) "R0")
dbCreateParamInstByMasterName(cv "PAD" "PAD60GU" "layout" "pad60gu_IBUF_IBIAS_bottom_9" list(250 0) "R0")
dbCreateParamInstByMasterName(cv "tphn28hpcpgv18" "PVSS1AC_V_G" "layout" "VSS_bottom_10" list(190 0) "R0")
dbCreateParamInstByMasterName(cv "PAD" "PAD60GU" "layout" "pad60gu_VSS_bottom_10" list(190 0) "R0")
dbCreateParamInstByMasterName(cv "tphn28hpcpgv18" "PDB3AC_V_G" "layout" "IBREF_bottom_11" list(130 0) "R0")
dbCreateParamInstByMasterName(cv "PAD" "PAD60GU" "layout" "pad60gu_IBREF_bottom_11" list(130 0) "R0")
dbCreateParamInstByMasterName(cv "tphn28hpcpgv18" "PCORNERA_G" "layout" "CORNER_BOTTOM_LEFT_bottom_left" list(0 0) "R0")
dbCreateParamInstByMasterName(cv "tphn28hpcpgv18" "PDB3AC_H_G" "layout" "VREFDES_left_0" list(0 150) "R270")
dbCreateParamInstByMasterName(cv "PAD" "PAD60GU" "layout" "pad60gu_VREFDES_left_0" list(0 150) "R270")
dbCreateParamInstByMasterName(cv "tphn28hpcpgv18" "PVDD1AC_H_G" "layout" "VDD_CDAC_left_1" list(0 210) "R270")
dbCreateParamInstByMasterName(cv "PAD" "PAD60GU" "layout" "pad60gu_VDD_CDAC_left_1" list(0 210) "R270")
dbCreateParamInstByMasterName(cv "tphn28hpcpgv18" "PDB3AC_H_G" "layout" "IB12_left_2" list(0 270) "R270")
dbCreateParamInstByMasterName(cv "PAD" "PAD60GU" "layout" "pad60gu_IB12_left_2" list(0 270) "R270")
dbCreateParamInstByMasterName(cv "tphn28hpcpgv18" "PVDD1AC_H_G" "layout" "VDD12_left_3" list(0 330) "R270")
dbCreateParamInstByMasterName(cv "PAD" "PAD60GU" "layout" "pad60gu_VDD12_left_3" list(0 330) "R270")
dbCreateParamInstByMasterName(cv "tphn28hpcpgv18" "PDB3AC_H_G" "layout" "IB3_left_4" list(0 390) "R270")
dbCreateParamInstByMasterName(cv "PAD" "PAD60GU" "layout" "pad60gu_IB3_left_4" list(0 390) "R270")
dbCreateParamInstByMasterName(cv "tphn28hpcpgv18" "PVDD1AC_H_G" "layout" "VDD3_left_5" list(0 450) "R270")
dbCreateParamInstByMasterName(cv "PAD" "PAD60GU" "layout" "pad60gu_VDD3_left_5" list(0 450) "R270")
dbCreateParamInstByMasterName(cv "tphn28hpcpgv18" "PVSS1DGZ_H_G" "layout" "GIOL_left_6" list(0 510) "R270")
dbCreateParamInstByMasterName(cv "PAD" "PAD60GU" "layout" "pad60gu_GIOL_left_6" list(0 510) "R270")
dbCreateParamInstByMasterName(cv "tphn28hpcpgv18" "PVDD1DGZ_H_G" "layout" "VIOL_left_7" list(0 570) "R270")
dbCreateParamInstByMasterName(cv "PAD" "PAD60GU" "layout" "pad60gu_VIOL_left_7" list(0 570) "R270")
dbCreateParamInstByMasterName(cv "tphn28hpcpgv18" "PVSS2DGZ_H_G" "layout" "GIOH_left_8" list(0 630) "R270")
dbCreateParamInstByMasterName(cv "PAD" "PAD60GU" "layout" "pad60gu_GIOH_left_8" list(0 630) "R270")
dbCreateParamInstByMasterName(cv "tphn28hpcpgv18" "PVDD2POC_H_G" "layout" "VIOH_left_9" list(0 690) "R270")
dbCreateParamInstByMasterName(cv "PAD" "PAD60GU" "layout" "pad60gu_VIOH_left_9" list(0 690) "R270")
dbCreateParamInstByMasterName(cv "tphn28hpcpgv18" "PDDW16SDGZ_H_G" "layout" "SYNC_left_10" list(0 750) "R270")
dbCreateParamInstByMasterName(cv "PAD" "PAD60GU" "layout" "pad60gu_SYNC_left_10" list(0 750) "R270")
dbCreateParamInstByMasterName(cv "tphn28hpcpgv18" "PDDW16SDGZ_H_G" "layout" "DCLK_left_11" list(0 810) "R270")
dbCreateParamInstByMasterName(cv "PAD" "PAD60GU" "layout" "pad60gu_DCLK_left_11" list(0 810) "R270")
dbCreateParamInstByMasterName(cv "tphn28hpcpgv18" "PCORNER_G" "layout" "CORNER_TOP_LEFT_top_left" list(0 940) "R270")

; ==================== Filler Components ====================
dbCreateParamInstByMasterName(cv "tphn28hpcpgv18" "PFILLER20A_G" "layout" "sep_bottom_right_corner" list(810 0) "R0")
dbCreateParamInstByMasterName(cv "tphn28hpcpgv18" "PFILLER20A_G" "layout" "filler_bottom_left_corner" list(110 0) "R0")
dbCreateParamInstByMasterName(cv "tphn28hpcpgv18" "PFILLER20A_G" "layout" "filler_R0_1_1" list(770 0) "R0")
dbCreateParamInstByMasterName(cv "tphn28hpcpgv18" "PFILLER20A_G" "layout" "filler_R0_1_2" list(750 0) "R0")
dbCreateParamInstByMasterName(cv "tphn28hpcpgv18" "PRCUTA_G" "layout" "filler_R0_2_1" list(710 0) "R0")
dbCreateParamInstByMasterName(cv "tphn28hpcpgv18" "PRCUTA_G" "layout" "filler_R0_2_2" list(690 0) "R0")
dbCreateParamInstByMasterName(cv "tphn28hpcpgv18" "PFILLER20A_G" "layout" "filler_R0_3_1" list(650 0) "R0")
dbCreateParamInstByMasterName(cv "tphn28hpcpgv18" "PFILLER20A_G" "layout" "filler_R0_3_2" list(630 0) "R0")
dbCreateParamInstByMasterName(cv "tphn28hpcpgv18" "PFILLER20A_G" "layout" "filler_R0_4_1" list(590 0) "R0")
dbCreateParamInstByMasterName(cv "tphn28hpcpgv18" "PFILLER20A_G" "layout" "filler_R0_4_2" list(570 0) "R0")
dbCreateParamInstByMasterName(cv "tphn28hpcpgv18" "PFILLER20A_G" "layout" "filler_R0_5_1" list(530 0) "R0")
dbCreateParamInstByMasterName(cv "tphn28hpcpgv18" "PFILLER20A_G" "layout" "filler_R0_5_2" list(510 0) "R0")
dbCreateParamInstByMasterName(cv "tphn28hpcpgv18" "PFILLER20A_G" "layout" "filler_R0_6_1" list(470 0) "R0")
dbCreateParamInstByMasterName(cv "tphn28hpcpgv18" "PFILLER20A_G" "layout" "filler_R0_6_2" list(450 0) "R0")
dbCreateParamInstByMasterName(cv "tphn28hpcpgv18" "PFILLER20A_G" "layout" "filler_R0_7_1" list(410 0) "R0")
dbCreateParamInstByMasterName(cv "tphn28hpcpgv18" "PFILLER20A_G" "layout" "filler_R0_7_2" list(390 0) "R0")
dbCreateParamInstByMasterName(cv "tphn28hpcpgv18" "PFILLER20A_G" "layout" "filler_R0_8_1" list(350 0) "R0")
dbCreateParamInstByMasterName(cv "tphn28hpcpgv18" "PFILLER20A_G" "layout" "filler_R0_8_2" list(330 0) "R0")
dbCreateParamInstByMasterName(cv "tphn28hpcpgv18" "PFILLER20A_G" "layout" "filler_R0_9_1" list(290 0) "R0")
dbCreateParamInstByMasterName(cv "tphn28hpcpgv18" "PFILLER20A_G" "layout" "filler_R0_9_2" list(270 0) "R0")
dbCreateParamInstByMasterName(cv "tphn28hpcpgv18" "PFILLER20A_G" "layout" "filler_R0_10_1" list(230 0) "R0")
dbCreateParamInstByMasterName(cv "tphn28hpcpgv18" "PFILLER20A_G" "layout" "filler_R0_10_2" list(210 0) "R0")
dbCreateParamInstByMasterName(cv "tphn28hpcpgv18" "PFILLER20A_G" "layout" "filler_R0_11_1" list(170 0) "R0")
dbCreateParamInstByMasterName(cv "tphn28hpcpgv18" "PFILLER20A_G" "layout" "filler_R0_11_2" list(150 0) "R0")
dbCreateParamInstByMasterName(cv "tphn28hpcpgv18" "PFILLER20A_G" "layout" "filler_right_top_corner" list(940 810) "R90")
dbCreateParamInstByMasterName(cv "tphn28hpcpgv18" "PFILLER20A_G" "layout" "filler_right_bottom_corner" list(940 110) "R90")
dbCreateParamInstByMasterName(cv "tphn28hpcpgv18" "PFILLER20A_G" "layout" "filler_R90_1_1" list(940 770) "R90")
dbCreateParamInstByMasterName(cv "tphn28hpcpgv18" "PFILLER20A_G" "layout" "filler_R90_1_2" list(940 750) "R90")
dbCreateParamInstByMasterName(cv "tphn28hpcpgv18" "PFILLER20A_G" "layout" "filler_R90_2_1" list(940 710) "R90")
dbCreateParamInstByMasterName(cv "tphn28hpcpgv18" "PFILLER20A_G" "layout" "filler_R90_2_2" list(940 690) "R90")
dbCreateParamInstByMasterName(cv "tphn28hpcpgv18" "PRCUTA_G" "layout" "filler_R90_3_1" list(940 650) "R90")
dbCreateParamInstByMasterName(cv "tphn28hpcpgv18" "PRCUTA_G" "layout" "filler_R90_3_2" list(940 630) "R90")
dbCreateParamInstByMasterName(cv "tphn28hpcpgv18" "PFILLER20A_G" "layout" "filler_R90_4_1" list(940 590) "R90")
dbCreateParamInstByMasterName(cv "tphn28hpcpgv18" "PFILLER20A_G" "layout" "filler_R90_4_2" list(940 570) "R90")
dbCreateParamInstByMasterName(cv "tphn28hpcpgv18" "PFILLER20A_G" "layout" "filler_R90_5_1" list(940 530) "R90")
dbCreateParamInstByMasterName(cv "tphn28hpcpgv18" "PFILLER20A_G" "layout" "filler_R90_5_2" list(940 510) "R90")
dbCreateParamInstByMasterName(cv "tphn28hpcpgv18" "PFILLER20A_G" "layout" "filler_R90_6_1" list(940 470) "R90")
dbCreateParamInstByMasterName(cv "tphn28hpcpgv18" "PFILLER20A_G" "layout" "filler_R90_6_2" list(940 450) "R90")
dbCreateParamInstByMasterName(cv "tphn28hpcpgv18" "PFILLER20A_G" "layout" "filler_R90_7_1" list(940 410) "R90")
dbCreateParamInstByMasterName(cv "tphn28hpcpgv18" "PFILLER20A_G" "layout" "filler_R90_7_2" list(940 390) "R90")
dbCreateParamInstByMasterName(cv "tphn28hpcpgv18" "PFILLER20A_G" "layout" "filler_R90_8_1" list(940 350) "R90")
dbCreateParamInstByMasterName(cv "tphn28hpcpgv18" "PFILLER20A_G" "layout" "filler_R90_8_2" list(940 330) "R90")
dbCreateParamInstByMasterName(cv "tphn28hpcpgv18" "PFILLER20A_G" "layout" "filler_R90_9_1" list(940 290) "R90")
dbCreateParamInstByMasterName(cv "tphn28hpcpgv18" "PFILLER20A_G" "layout" "filler_R90_9_2" list(940 270) "R90")
dbCreateParamInstByMasterName(cv "tphn28hpcpgv18" "PRCUTA_G" "layout" "filler_R90_10_1" list(940 230) "R90")
dbCreateParamInstByMasterName(cv "tphn28hpcpgv18" "PRCUTA_G" "layout" "filler_R90_10_2" list(940 210) "R90")
dbCreateParamInstByMasterName(cv "tphn28hpcpgv18" "PFILLER20A_G" "layout" "filler_R90_11_1" list(940 170) "R90")
dbCreateParamInstByMasterName(cv "tphn28hpcpgv18" "PFILLER20A_G" "layout" "filler_R90_11_2" list(940 150) "R90")
dbCreateParamInstByMasterName(cv "tphn28hpcpgv18" "PFILLER20_G" "layout" "sep_top_left_corner" list(130 940) "R180")
dbCreateParamInstByMasterName(cv "tphn28hpcpgv18" "PFILLER20A_G" "layout" "filler_top_right_corner" list(830 940) "R180")
dbCreateParamInstByMasterName(cv "tphn28hpcpgv18" "PFILLER20_G" "layout" "filler_R180_1_1" list(170 940) "R180")
dbCreateParamInstByMasterName(cv "tphn28hpcpgv18" "PFILLER20_G" "layout" "filler_R180_1_2" list(190 940) "R180")
dbCreateParamInstByMasterName(cv "tphn28hpcpgv18" "PFILLER20_G" "layout" "filler_R180_2_1" list(230 940) "R180")
dbCreateParamInstByMasterName(cv "tphn28hpcpgv18" "PFILLER20_G" "layout" "filler_R180_2_2" list(250 940) "R180")
dbCreateParamInstByMasterName(cv "tphn28hpcpgv18" "PFILLER20_G" "layout" "filler_R180_3_1" list(290 940) "R180")
dbCreateParamInstByMasterName(cv "tphn28hpcpgv18" "PFILLER20_G" "layout" "filler_R180_3_2" list(310 940) "R180")
dbCreateParamInstByMasterName(cv "tphn28hpcpgv18" "PFILLER20_G" "layout" "filler_R180_4_1" list(350 940) "R180")
dbCreateParamInstByMasterName(cv "tphn28hpcpgv18" "PFILLER20_G" "layout" "filler_R180_4_2" list(370 940) "R180")
dbCreateParamInstByMasterName(cv "tphn28hpcpgv18" "PFILLER20_G" "layout" "filler_R180_5_1" list(410 940) "R180")
dbCreateParamInstByMasterName(cv "tphn28hpcpgv18" "PFILLER20_G" "layout" "filler_R180_5_2" list(430 940) "R180")
dbCreateParamInstByMasterName(cv "tphn28hpcpgv18" "PFILLER20_G" "layout" "filler_R180_6_1" list(470 940) "R180")
dbCreateParamInstByMasterName(cv "tphn28hpcpgv18" "PFILLER20_G" "layout" "filler_R180_6_2" list(490 940) "R180")
dbCreateParamInstByMasterName(cv "tphn28hpcpgv18" "PFILLER20_G" "layout" "filler_R180_7_1" list(530 940) "R180")
dbCreateParamInstByMasterName(cv "tphn28hpcpgv18" "PFILLER20_G" "layout" "filler_R180_7_2" list(550 940) "R180")
dbCreateParamInstByMasterName(cv "tphn28hpcpgv18" "PFILLER20_G" "layout" "filler_R180_8_1" list(590 940) "R180")
dbCreateParamInstByMasterName(cv "tphn28hpcpgv18" "PFILLER20_G" "layout" "filler_R180_8_2" list(610 940) "R180")
dbCreateParamInstByMasterName(cv "tphn28hpcpgv18" "PFILLER20_G" "layout" "filler_R180_9_1" list(650 940) "R180")
dbCreateParamInstByMasterName(cv "tphn28hpcpgv18" "PFILLER20_G" "layout" "filler_R180_9_2" list(670 940) "R180")
dbCreateParamInstByMasterName(cv "tphn28hpcpgv18" "PRCUTA_G" "layout" "filler_R180_10_1" list(710 940) "R180")
dbCreateParamInstByMasterName(cv "tphn28hpcpgv18" "PRCUTA_G" "layout" "filler_R180_10_2" list(730 940) "R180")
dbCreateParamInstByMasterName(cv "tphn28hpcpgv18" "PFILLER20A_G" "layout" "filler_R180_11_1" list(770 940) "R180")
dbCreateParamInstByMasterName(cv "tphn28hpcpgv18" "PFILLER20A_G" "layout" "filler_R180_11_2" list(790 940) "R180")
dbCreateParamInstByMasterName(cv "tphn28hpcpgv18" "PFILLER20A_G" "layout" "filler_left_bottom_corner" list(0 130) "R270")
dbCreateParamInstByMasterName(cv "tphn28hpcpgv18" "PFILLER20_G" "layout" "sep_left_top_corner" list(0 830) "R270")
dbCreateParamInstByMasterName(cv "tphn28hpcpgv18" "PFILLER20A_G" "layout" "filler_R270_1_1" list(0 170) "R270")
dbCreateParamInstByMasterName(cv "tphn28hpcpgv18" "PFILLER20A_G" "layout" "filler_R270_1_2" list(0 190) "R270")
dbCreateParamInstByMasterName(cv "tphn28hpcpgv18" "PFILLER20A_G" "layout" "filler_R270_2_1" list(0 230) "R270")
dbCreateParamInstByMasterName(cv "tphn28hpcpgv18" "PFILLER20A_G" "layout" "filler_R270_2_2" list(0 250) "R270")
dbCreateParamInstByMasterName(cv "tphn28hpcpgv18" "PFILLER20A_G" "layout" "filler_R270_3_1" list(0 290) "R270")
dbCreateParamInstByMasterName(cv "tphn28hpcpgv18" "PFILLER20A_G" "layout" "filler_R270_3_2" list(0 310) "R270")
dbCreateParamInstByMasterName(cv "tphn28hpcpgv18" "PFILLER20A_G" "layout" "filler_R270_4_1" list(0 350) "R270")
dbCreateParamInstByMasterName(cv "tphn28hpcpgv18" "PFILLER20A_G" "layout" "filler_R270_4_2" list(0 370) "R270")
dbCreateParamInstByMasterName(cv "tphn28hpcpgv18" "PFILLER20A_G" "layout" "filler_R270_5_1" list(0 410) "R270")
dbCreateParamInstByMasterName(cv "tphn28hpcpgv18" "PFILLER20A_G" "layout" "filler_R270_5_2" list(0 430) "R270")
dbCreateParamInstByMasterName(cv "tphn28hpcpgv18" "PRCUTA_G" "layout" "filler_R270_6_1" list(0 470) "R270")
dbCreateParamInstByMasterName(cv "tphn28hpcpgv18" "PRCUTA_G" "layout" "filler_R270_6_2" list(0 490) "R270")
dbCreateParamInstByMasterName(cv "tphn28hpcpgv18" "PFILLER20_G" "layout" "filler_R270_7_1" list(0 530) "R270")
dbCreateParamInstByMasterName(cv "tphn28hpcpgv18" "PFILLER20_G" "layout" "filler_R270_7_2" list(0 550) "R270")
dbCreateParamInstByMasterName(cv "tphn28hpcpgv18" "PFILLER20_G" "layout" "filler_R270_8_1" list(0 590) "R270")
dbCreateParamInstByMasterName(cv "tphn28hpcpgv18" "PFILLER20_G" "layout" "filler_R270_8_2" list(0 610) "R270")
dbCreateParamInstByMasterName(cv "tphn28hpcpgv18" "PFILLER20_G" "layout" "filler_R270_9_1" list(0 650) "R270")
dbCreateParamInstByMasterName(cv "tphn28hpcpgv18" "PFILLER20_G" "layout" "filler_R270_9_2" list(0 670) "R270")
dbCreateParamInstByMasterName(cv "tphn28hpcpgv18" "PFILLER20_G" "layout" "filler_R270_10_1" list(0 710) "R270")
dbCreateParamInstByMasterName(cv "tphn28hpcpgv18" "PFILLER20_G" "layout" "filler_R270_10_2" list(0 730) "R270")
dbCreateParamInstByMasterName(cv "tphn28hpcpgv18" "PFILLER20_G" "layout" "filler_R270_11_1" list(0 770) "R270")
dbCreateParamInstByMasterName(cv "tphn28hpcpgv18" "PFILLER20_G" "layout" "filler_R270_11_2" list(0 790) "R270")

; ==================== Digital IO Features (with Inner Pad Support) ====================
dbCreatePath(cv list("M3" "drawing") list(list(130 829.5) list(690 829.5)) 0.2)
dbCreatePath(cv list("M3" "drawing") list(list(130 830.76) list(690 830.76)) 0.2)
dbCreatePath(cv list("M3" "drawing") list(list(110.5 490) list(110.5 810)) 0.2)
dbCreatePath(cv list("M3" "drawing") list(list(109.24 490) list(109.24 810)) 0.2)
dbCreatePath(cv list("M3" "drawing") list(list(130 829.5) list(110.5 829.5)) 0.2 "extendExtend")
dbCreatePath(cv list("M3" "drawing") list(list(110.5 829.5) list(110.5 810)) 0.2 "extendExtend")
dbCreatePath(cv list("M3" "drawing") list(list(130 830.76) list(109.24 830.76)) 0.2 "extendExtend")
dbCreatePath(cv list("M3" "drawing") list(list(109.24 830.76) list(109.24 810)) 0.2 "extendExtend")
dbCreatePath(cv list("M3" "drawing") list(list(110.12 507.61) list(109.24 507.61)) 0.2)
tech = techGetTechFile(cv)
viaParams = list(list("cutRows" 2) list("cutColumns" 4))
viaDefId = techFindViaDefByName(tech "M3_M2")
newVia = dbCreateVia(cv viaDefId list(110.12 507.61) "R270" viaParams)
dbCreatePath(cv list("M3" "drawing") list(list(110.12 567.655) list(110.5 567.655)) 0.2)
tech = techGetTechFile(cv)
viaParams = list(list("cutRows" 2) list("cutColumns" 4))
viaDefId = techFindViaDefByName(tech "M3_M2")
newVia = dbCreateVia(cv viaDefId list(110.12 567.655) "R270" viaParams)
dbCreatePath(cv list("M3" "drawing") list(list(139.8 830.125) list(139.8 829.5)) 0.26)
dbCreatePath(cv list("M3" "drawing") list(list(144.1 830.125) list(144.1 830.76)) 0.26)
dbCreateLabel(cv list("M4" "pin") list(148.275 830.125) "D4_CORE" "centerRight" "R90" "roman" 2)
dbCreatePath(cv list("M3" "drawing") list(list(199.8 830.125) list(199.8 829.5)) 0.26)
dbCreatePath(cv list("M3" "drawing") list(list(204.1 830.125) list(204.1 830.76)) 0.26)
dbCreateLabel(cv list("M4" "pin") list(208.275 830.125) "D3_CORE" "centerRight" "R90" "roman" 2)
dbCreatePath(cv list("M3" "drawing") list(list(259.8 830.125) list(259.8 829.5)) 0.26)
dbCreatePath(cv list("M3" "drawing") list(list(264.1 830.125) list(264.1 830.76)) 0.26)
dbCreateLabel(cv list("M4" "pin") list(268.275 830.125) "D2_CORE" "centerRight" "R90" "roman" 2)
dbCreatePath(cv list("M3" "drawing") list(list(319.8 830.125) list(319.8 829.5)) 0.26)
dbCreatePath(cv list("M3" "drawing") list(list(324.1 830.125) list(324.1 830.76)) 0.26)
dbCreateLabel(cv list("M4" "pin") list(328.275 830.125) "D1_CORE" "centerRight" "R90" "roman" 2)
dbCreatePath(cv list("M3" "drawing") list(list(379.8 830.125) list(379.8 829.5)) 0.26)
dbCreatePath(cv list("M3" "drawing") list(list(384.1 830.125) list(384.1 830.76)) 0.26)
dbCreateLabel(cv list("M4" "pin") list(388.275 830.125) "D0_CORE" "centerRight" "R90" "roman" 2)
dbCreatePath(cv list("M3" "drawing") list(list(439.8 830.125) list(439.8 830.76)) 0.26)
dbCreatePath(cv list("M3" "drawing") list(list(448.275 830.125) list(448.275 830.76)) 0.26)
dbCreatePath(cv list("M3" "drawing") list(list(444.1 830.125) list(444.1 829.5)) 0.26)
dbCreateLabel(cv list("M4" "pin") list(435.67 830.125) "RST_CORE" "centerRight" "R90" "roman" 2)
dbCreatePath(cv list("M3" "drawing") list(list(499.8 830.125) list(499.8 829.5)) 0.26)
dbCreatePath(cv list("M3" "drawing") list(list(504.1 830.125) list(504.1 830.76)) 0.26)
dbCreateLabel(cv list("M4" "pin") list(508.275 830.125) "SDO_CORE" "centerRight" "R90" "roman" 2)
dbCreatePath(cv list("M3" "drawing") list(list(559.8 830.125) list(559.8 830.76)) 0.26)
dbCreatePath(cv list("M3" "drawing") list(list(568.275 830.125) list(568.275 830.76)) 0.26)
dbCreatePath(cv list("M3" "drawing") list(list(564.1 830.125) list(564.1 829.5)) 0.26)
dbCreateLabel(cv list("M4" "pin") list(555.67 830.125) "SCK_CORE" "centerRight" "R90" "roman" 2)
dbCreatePath(cv list("M3" "drawing") list(list(619.8 830.125) list(619.8 830.76)) 0.26)
dbCreatePath(cv list("M3" "drawing") list(list(628.275 830.125) list(628.275 830.76)) 0.26)
dbCreatePath(cv list("M3" "drawing") list(list(624.1 830.125) list(624.1 829.5)) 0.26)
dbCreateLabel(cv list("M4" "pin") list(615.67 830.125) "SDI_CORE" "centerRight" "R90" "roman" 2)
dbCreatePath(cv list("M3" "drawing") list(list(679.8 830.125) list(679.8 830.76)) 0.26)
dbCreatePath(cv list("M3" "drawing") list(list(688.275 830.125) list(688.275 830.76)) 0.26)
dbCreatePath(cv list("M3" "drawing") list(list(684.1 830.125) list(684.1 829.5)) 0.26)
dbCreateLabel(cv list("M4" "pin") list(675.67 830.125) "SLP_CORE" "centerRight" "R90" "roman" 2)
dbCreatePath(cv list("M3" "drawing") list(list(109.875 739.8) list(109.24 739.8)) 0.26)
dbCreatePath(cv list("M3" "drawing") list(list(109.875 748.275) list(109.24 748.275)) 0.26)
dbCreatePath(cv list("M3" "drawing") list(list(109.875 744.1) list(110.5 744.1)) 0.26)
dbCreateLabel(cv list("M4" "pin") list(109.875 735.67) "SYNC_CORE" "centerLeft" "R0" "roman" 2)
dbCreatePath(cv list("M3" "drawing") list(list(109.875 799.8) list(110.5 799.8)) 0.26)
dbCreatePath(cv list("M3" "drawing") list(list(109.875 804.1) list(109.24 804.1)) 0.26)
dbCreateLabel(cv list("M4" "pin") list(109.875 808.275) "DCLK_CORE" "centerLeft" "R0" "roman" 2)

; ==================== Pin Labels (with Inner Pad Support) ====================
dbCreateLabel(cv list("AP" "pin") list(140 951) "D4" "centerLeft" "R90" "roman" 10)
dbCreateLabel(cv list("AP" "pin") list(200 951) "D3" "centerLeft" "R90" "roman" 10)
dbCreateLabel(cv list("AP" "pin") list(260 951) "D2" "centerLeft" "R90" "roman" 10)
dbCreateLabel(cv list("AP" "pin") list(320 951) "D1" "centerLeft" "R90" "roman" 10)
dbCreateLabel(cv list("AP" "pin") list(380 951) "D0" "centerLeft" "R90" "roman" 10)
dbCreateLabel(cv list("AP" "pin") list(440 951) "RST" "centerLeft" "R90" "roman" 10)
dbCreateLabel(cv list("AP" "pin") list(500 951) "SDO" "centerLeft" "R90" "roman" 10)
dbCreateLabel(cv list("AP" "pin") list(560 951) "SCK" "centerLeft" "R90" "roman" 10)
dbCreateLabel(cv list("AP" "pin") list(620 951) "SDI" "centerLeft" "R90" "roman" 10)
dbCreateLabel(cv list("AP" "pin") list(680 951) "SLP" "centerLeft" "R90" "roman" 10)
dbCreateLabel(cv list("AP" "pin") list(740 951) "VREFDES2" "centerLeft" "R90" "roman" 10)
dbCreateLabel(cv list("AP" "pin") list(800 951) "IBREF2" "centerLeft" "R90" "roman" 10)
dbCreateLabel(cv list("AP" "pin") list(951 800) "VREFN" "centerLeft" "R0" "roman" 10)
dbCreateLabel(cv list("M2" "pin") list(830.1 800) "VREFN_CORE" "centerRight" "R0" "roman" 2)
dbCreateLabel(cv list("AP" "pin") list(951 740) "VREFM" "centerLeft" "R0" "roman" 10)
dbCreateLabel(cv list("AP" "pin") list(951 680) "VREFH" "centerLeft" "R0" "roman" 10)
dbCreateLabel(cv list("M2" "pin") list(830.1 680) "VREFH_CORE" "centerRight" "R0" "roman" 2)
dbCreateLabel(cv list("AP" "pin") list(951 620) "VSSSAR" "centerLeft" "R0" "roman" 10)
dbCreateLabel(cv list("AP" "pin") list(951 560) "VDDSAR" "centerLeft" "R0" "roman" 10)
dbCreateLabel(cv list("AP" "pin") list(951 500) "VDDCLK" "centerLeft" "R0" "roman" 10)
dbCreateLabel(cv list("AP" "pin") list(951 440) "VSSCLK" "centerLeft" "R0" "roman" 10)
dbCreateLabel(cv list("AP" "pin") list(951 380) "VCM" "centerLeft" "R0" "roman" 10)
dbCreateLabel(cv list("AP" "pin") list(951 320) "VDD_DAT" "centerLeft" "R0" "roman" 10)
dbCreateLabel(cv list("M2" "pin") list(830.1 320) "VDD_DAT_CORE" "centerRight" "R0" "roman" 2)
dbCreateLabel(cv list("AP" "pin") list(951 260) "GND_DAT" "centerLeft" "R0" "roman" 10)
dbCreateLabel(cv list("M2" "pin") list(830.1 260) "GND_DAT_CORE" "centerRight" "R0" "roman" 2)
dbCreateLabel(cv list("AP" "pin") list(951 200) "CLKN" "centerLeft" "R0" "roman" 10)
dbCreateLabel(cv list("AP" "pin") list(951 140) "CLKP" "centerLeft" "R0" "roman" 10)
dbCreateLabel(cv list("AP" "pin") list(800 -11) "GND_CKB" "centerRight" "R90" "roman" 10)
dbCreateLabel(cv list("M2" "pin") list(800 109.9) "GND_CKB_CORE" "centerLeft" "R90" "roman" 2)
dbCreateLabel(cv list("AP" "pin") list(740 -11) "VDD_CKB" "centerRight" "R90" "roman" 10)
dbCreateLabel(cv list("M2" "pin") list(740 109.9) "VDD_CKB_CORE" "centerLeft" "R90" "roman" 2)
dbCreateLabel(cv list("AP" "pin") list(680 -11) "VINCM" "centerRight" "R90" "roman" 10)
dbCreateLabel(cv list("AP" "pin") list(620 -11) "VSSIB" "centerRight" "R90" "roman" 10)
dbCreateLabel(cv list("M2" "pin") list(620 109.9) "VSSIB_CORE" "centerLeft" "R90" "roman" 2)
dbCreateLabel(cv list("AP" "pin") list(560 -11) "VINP" "centerRight" "R90" "roman" 10)
dbCreateLabel(cv list("AP" "pin") list(500 -11) "VINN" "centerRight" "R90" "roman" 10)
dbCreateLabel(cv list("AP" "pin") list(440 -11) "VSSIB" "centerRight" "R90" "roman" 10)
dbCreateLabel(cv list("M2" "pin") list(440 109.9) "VSSIB_CORE" "centerLeft" "R90" "roman" 2)
dbCreateLabel(cv list("AP" "pin") list(380 -11) "VDDIB" "centerRight" "R90" "roman" 10)
dbCreateLabel(cv list("M2" "pin") list(380 109.9) "VDDIB_CORE" "centerLeft" "R90" "roman" 2)
dbCreateLabel(cv list("AP" "pin") list(320 -11) "VSS" "centerRight" "R90" "roman" 10)
dbCreateLabel(cv list("AP" "pin") list(260 -11) "IBUF_IBIAS" "centerRight" "R90" "roman" 10)
dbCreateLabel(cv list("AP" "pin") list(200 -11) "VSS" "centerRight" "R90" "roman" 10)
dbCreateLabel(cv list("AP" "pin") list(140 -11) "IBREF" "centerRight" "R90" "roman" 10)
dbCreateLabel(cv list("AP" "pin") list(-11 140) "VREFDES" "centerRight" "R0" "roman" 10)
dbCreateLabel(cv list("AP" "pin") list(-11 200) "VDD_CDAC" "centerRight" "R0" "roman" 10)
dbCreateLabel(cv list("AP" "pin") list(-11 260) "IB12" "centerRight" "R0" "roman" 10)
dbCreateLabel(cv list("AP" "pin") list(-11 320) "VDD12" "centerRight" "R0" "roman" 10)
dbCreateLabel(cv list("AP" "pin") list(-11 380) "IB3" "centerRight" "R0" "roman" 10)
dbCreateLabel(cv list("AP" "pin") list(-11 440) "VDD3" "centerRight" "R0" "roman" 10)
dbCreateLabel(cv list("AP" "pin") list(-11 500) "GIOL" "centerRight" "R0" "roman" 10)
dbCreateLabel(cv list("AP" "pin") list(-11 560) "VIOL" "centerRight" "R0" "roman" 10)
dbCreateLabel(cv list("AP" "pin") list(-11 620) "GIOH" "centerRight" "R0" "roman" 10)
dbCreateLabel(cv list("AP" "pin") list(-11 680) "VIOH" "centerRight" "R0" "roman" 10)
dbCreateLabel(cv list("AP" "pin") list(-11 740) "SYNC" "centerRight" "R0" "roman" 10)
dbCreateLabel(cv list("AP" "pin") list(-11 800) "DCLK" "centerRight" "R0" "roman" 10)

dbSave(cv)
t
