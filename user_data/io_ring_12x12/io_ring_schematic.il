cv = geGetWindowCellView()
pddw16sdgz_v_gMaster = dbOpenCellView("tphn28hpcpgv18" "PDDW16SDGZ_V_G" "symbol")
dbCreateInst(cv pddw16sdgz_v_gMaster "D4_top0" '(3.6875 28.0) "R180")
schCreateWire(cv "route" "full" '((3.562 27.000) (3.562 26.250)) 0 0 0 nil nil)
schCreateWireLabel(cv nil '(3.562 26.750) "VIOL" "lowerRight" "R90" "stick" 0.0625 nil)
noConnMaster = dbOpenCellView("basic" "noConn" "symbol")
schCreateWire(cv "route" "full" '((3.438 27.000) (3.438 26.250)) 0 0 0 nil nil)
dbCreateInst(cv noConnMaster "noConn_D4_top0_C" '(3.438 26.250) "R0")
schCreateWire(cv "route" "full" '((3.812 27.000) (3.812 26.250)) 0 0 0 nil nil)
schCreateWireLabel(cv nil '(3.812 26.750) "GIOL" "lowerRight" "R90" "stick" 0.0625 nil)
schCreateWire(cv "route" "full" '((3.938 27.000) (3.938 26.250)) 0 0 0 nil nil)
schCreateWireLabel(cv nil '(3.938 26.750) "D4_CORE" "lowerRight" "R90" "stick" 0.0625 nil)
schCreatePin(cv nil "D4_CORE" "inputOutput" nil '(3.938 26.250) "R90")
schCreateWire(cv "route" "full" '((3.000 28.000) (3.000 28.750)) 0 0 0 nil nil)
schCreateWireLabel(cv nil '(3.000 28.250) "D4" "lowerLeft" "R90" "stick" 0.0625 nil)
schCreatePin(cv nil "D4" "inputOutput" nil '(3.000 28.750) "R270")
schCreateWire(cv "route" "full" '((3.312 27.000) (3.312 26.250)) 0 0 0 nil nil)
schCreateWireLabel(cv nil '(3.312 26.750) "POC" "lowerRight" "R90" "stick" 0.0625 nil)
schCreateWire(cv "route" "full" '((3.125 27.000) (3.125 26.250)) 0 0 0 nil nil)
schCreateWireLabel(cv nil '(3.125 26.750) "VIOL" "lowerRight" "R90" "stick" 0.0625 nil)
schCreateWire(cv "route" "full" '((2.938 27.000) (2.938 26.250)) 0 0 0 nil nil)
schCreateWireLabel(cv nil '(2.938 26.750) "GIOL" "lowerRight" "R90" "stick" 0.0625 nil)
schCreateWire(cv "route" "full" '((2.750 27.000) (2.750 26.250)) 0 0 0 nil nil)
schCreateWireLabel(cv nil '(2.750 26.750) "VIOH" "lowerRight" "R90" "stick" 0.0625 nil)
schCreateWire(cv "route" "full" '((2.375 27.000) (2.375 26.250)) 0 0 0 nil nil)
schCreateWireLabel(cv nil '(2.375 26.750) "GIOH" "lowerRight" "R90" "stick" 0.0625 nil)
dbCreateInst(cv pddw16sdgz_v_gMaster "D3_top1" '(5.6875 28.0) "R180")
schCreateWire(cv "route" "full" '((5.562 27.000) (5.562 26.250)) 0 0 0 nil nil)
schCreateWireLabel(cv nil '(5.562 26.750) "VIOL" "lowerRight" "R90" "stick" 0.0625 nil)
schCreateWire(cv "route" "full" '((5.438 27.000) (5.438 26.250)) 0 0 0 nil nil)
dbCreateInst(cv noConnMaster "noConn_D3_top1_C" '(5.438 26.250) "R0")
schCreateWire(cv "route" "full" '((5.812 27.000) (5.812 26.250)) 0 0 0 nil nil)
schCreateWireLabel(cv nil '(5.812 26.750) "GIOL" "lowerRight" "R90" "stick" 0.0625 nil)
schCreateWire(cv "route" "full" '((5.938 27.000) (5.938 26.250)) 0 0 0 nil nil)
schCreateWireLabel(cv nil '(5.938 26.750) "D3_CORE" "lowerRight" "R90" "stick" 0.0625 nil)
schCreatePin(cv nil "D3_CORE" "inputOutput" nil '(5.938 26.250) "R90")
schCreateWire(cv "route" "full" '((5.000 28.000) (5.000 28.750)) 0 0 0 nil nil)
schCreateWireLabel(cv nil '(5.000 28.250) "D3" "lowerLeft" "R90" "stick" 0.0625 nil)
schCreatePin(cv nil "D3" "inputOutput" nil '(5.000 28.750) "R270")
schCreateWire(cv "route" "full" '((5.312 27.000) (5.312 26.250)) 0 0 0 nil nil)
schCreateWireLabel(cv nil '(5.312 26.750) "POC" "lowerRight" "R90" "stick" 0.0625 nil)
schCreateWire(cv "route" "full" '((5.125 27.000) (5.125 26.250)) 0 0 0 nil nil)
schCreateWireLabel(cv nil '(5.125 26.750) "VIOL" "lowerRight" "R90" "stick" 0.0625 nil)
schCreateWire(cv "route" "full" '((4.938 27.000) (4.938 26.250)) 0 0 0 nil nil)
schCreateWireLabel(cv nil '(4.938 26.750) "GIOL" "lowerRight" "R90" "stick" 0.0625 nil)
schCreateWire(cv "route" "full" '((4.750 27.000) (4.750 26.250)) 0 0 0 nil nil)
schCreateWireLabel(cv nil '(4.750 26.750) "VIOH" "lowerRight" "R90" "stick" 0.0625 nil)
schCreateWire(cv "route" "full" '((4.375 27.000) (4.375 26.250)) 0 0 0 nil nil)
schCreateWireLabel(cv nil '(4.375 26.750) "GIOH" "lowerRight" "R90" "stick" 0.0625 nil)
dbCreateInst(cv pddw16sdgz_v_gMaster "D2_top2" '(7.6875 28.0) "R180")
schCreateWire(cv "route" "full" '((7.562 27.000) (7.562 26.250)) 0 0 0 nil nil)
schCreateWireLabel(cv nil '(7.562 26.750) "VIOL" "lowerRight" "R90" "stick" 0.0625 nil)
schCreateWire(cv "route" "full" '((7.438 27.000) (7.438 26.250)) 0 0 0 nil nil)
dbCreateInst(cv noConnMaster "noConn_D2_top2_C" '(7.438 26.250) "R0")
schCreateWire(cv "route" "full" '((7.812 27.000) (7.812 26.250)) 0 0 0 nil nil)
schCreateWireLabel(cv nil '(7.812 26.750) "GIOL" "lowerRight" "R90" "stick" 0.0625 nil)
schCreateWire(cv "route" "full" '((7.938 27.000) (7.938 26.250)) 0 0 0 nil nil)
schCreateWireLabel(cv nil '(7.938 26.750) "D2_CORE" "lowerRight" "R90" "stick" 0.0625 nil)
schCreatePin(cv nil "D2_CORE" "inputOutput" nil '(7.938 26.250) "R90")
schCreateWire(cv "route" "full" '((7.000 28.000) (7.000 28.750)) 0 0 0 nil nil)
schCreateWireLabel(cv nil '(7.000 28.250) "D2" "lowerLeft" "R90" "stick" 0.0625 nil)
schCreatePin(cv nil "D2" "inputOutput" nil '(7.000 28.750) "R270")
schCreateWire(cv "route" "full" '((7.312 27.000) (7.312 26.250)) 0 0 0 nil nil)
schCreateWireLabel(cv nil '(7.312 26.750) "POC" "lowerRight" "R90" "stick" 0.0625 nil)
schCreateWire(cv "route" "full" '((7.125 27.000) (7.125 26.250)) 0 0 0 nil nil)
schCreateWireLabel(cv nil '(7.125 26.750) "VIOL" "lowerRight" "R90" "stick" 0.0625 nil)
schCreateWire(cv "route" "full" '((6.938 27.000) (6.938 26.250)) 0 0 0 nil nil)
schCreateWireLabel(cv nil '(6.938 26.750) "GIOL" "lowerRight" "R90" "stick" 0.0625 nil)
schCreateWire(cv "route" "full" '((6.750 27.000) (6.750 26.250)) 0 0 0 nil nil)
schCreateWireLabel(cv nil '(6.750 26.750) "VIOH" "lowerRight" "R90" "stick" 0.0625 nil)
schCreateWire(cv "route" "full" '((6.375 27.000) (6.375 26.250)) 0 0 0 nil nil)
schCreateWireLabel(cv nil '(6.375 26.750) "GIOH" "lowerRight" "R90" "stick" 0.0625 nil)
dbCreateInst(cv pddw16sdgz_v_gMaster "D1_top3" '(9.6875 28.0) "R180")
schCreateWire(cv "route" "full" '((9.562 27.000) (9.562 26.250)) 0 0 0 nil nil)
schCreateWireLabel(cv nil '(9.562 26.750) "VIOL" "lowerRight" "R90" "stick" 0.0625 nil)
schCreateWire(cv "route" "full" '((9.438 27.000) (9.438 26.250)) 0 0 0 nil nil)
dbCreateInst(cv noConnMaster "noConn_D1_top3_C" '(9.438 26.250) "R0")
schCreateWire(cv "route" "full" '((9.812 27.000) (9.812 26.250)) 0 0 0 nil nil)
schCreateWireLabel(cv nil '(9.812 26.750) "GIOL" "lowerRight" "R90" "stick" 0.0625 nil)
schCreateWire(cv "route" "full" '((9.938 27.000) (9.938 26.250)) 0 0 0 nil nil)
schCreateWireLabel(cv nil '(9.938 26.750) "D1_CORE" "lowerRight" "R90" "stick" 0.0625 nil)
schCreatePin(cv nil "D1_CORE" "inputOutput" nil '(9.938 26.250) "R90")
schCreateWire(cv "route" "full" '((8.999 28.000) (8.999 28.750)) 0 0 0 nil nil)
schCreateWireLabel(cv nil '(8.999 28.250) "D1" "lowerLeft" "R90" "stick" 0.0625 nil)
schCreatePin(cv nil "D1" "inputOutput" nil '(8.999 28.750) "R270")
schCreateWire(cv "route" "full" '((9.312 27.000) (9.312 26.250)) 0 0 0 nil nil)
schCreateWireLabel(cv nil '(9.312 26.750) "POC" "lowerRight" "R90" "stick" 0.0625 nil)
schCreateWire(cv "route" "full" '((9.126 27.000) (9.126 26.250)) 0 0 0 nil nil)
schCreateWireLabel(cv nil '(9.126 26.750) "VIOL" "lowerRight" "R90" "stick" 0.0625 nil)
schCreateWire(cv "route" "full" '((8.938 27.000) (8.938 26.250)) 0 0 0 nil nil)
schCreateWireLabel(cv nil '(8.938 26.750) "GIOL" "lowerRight" "R90" "stick" 0.0625 nil)
schCreateWire(cv "route" "full" '((8.749 27.000) (8.749 26.250)) 0 0 0 nil nil)
schCreateWireLabel(cv nil '(8.749 26.750) "VIOH" "lowerRight" "R90" "stick" 0.0625 nil)
schCreateWire(cv "route" "full" '((8.376 27.000) (8.376 26.250)) 0 0 0 nil nil)
schCreateWireLabel(cv nil '(8.376 26.750) "GIOH" "lowerRight" "R90" "stick" 0.0625 nil)
dbCreateInst(cv pddw16sdgz_v_gMaster "D0_top4" '(11.6875 28.0) "R180")
schCreateWire(cv "route" "full" '((11.562 27.000) (11.562 26.250)) 0 0 0 nil nil)
schCreateWireLabel(cv nil '(11.562 26.750) "VIOL" "lowerRight" "R90" "stick" 0.0625 nil)
schCreateWire(cv "route" "full" '((11.438 27.000) (11.438 26.250)) 0 0 0 nil nil)
dbCreateInst(cv noConnMaster "noConn_D0_top4_C" '(11.438 26.250) "R0")
schCreateWire(cv "route" "full" '((11.812 27.000) (11.812 26.250)) 0 0 0 nil nil)
schCreateWireLabel(cv nil '(11.812 26.750) "GIOL" "lowerRight" "R90" "stick" 0.0625 nil)
schCreateWire(cv "route" "full" '((11.938 27.000) (11.938 26.250)) 0 0 0 nil nil)
schCreateWireLabel(cv nil '(11.938 26.750) "D0_CORE" "lowerRight" "R90" "stick" 0.0625 nil)
schCreatePin(cv nil "D0_CORE" "inputOutput" nil '(11.938 26.250) "R90")
schCreateWire(cv "route" "full" '((10.999 28.000) (10.999 28.750)) 0 0 0 nil nil)
schCreateWireLabel(cv nil '(10.999 28.250) "D0" "lowerLeft" "R90" "stick" 0.0625 nil)
schCreatePin(cv nil "D0" "inputOutput" nil '(10.999 28.750) "R270")
schCreateWire(cv "route" "full" '((11.312 27.000) (11.312 26.250)) 0 0 0 nil nil)
schCreateWireLabel(cv nil '(11.312 26.750) "POC" "lowerRight" "R90" "stick" 0.0625 nil)
schCreateWire(cv "route" "full" '((11.126 27.000) (11.126 26.250)) 0 0 0 nil nil)
schCreateWireLabel(cv nil '(11.126 26.750) "VIOL" "lowerRight" "R90" "stick" 0.0625 nil)
schCreateWire(cv "route" "full" '((10.938 27.000) (10.938 26.250)) 0 0 0 nil nil)
schCreateWireLabel(cv nil '(10.938 26.750) "GIOL" "lowerRight" "R90" "stick" 0.0625 nil)
schCreateWire(cv "route" "full" '((10.749 27.000) (10.749 26.250)) 0 0 0 nil nil)
schCreateWireLabel(cv nil '(10.749 26.750) "VIOH" "lowerRight" "R90" "stick" 0.0625 nil)
schCreateWire(cv "route" "full" '((10.376 27.000) (10.376 26.250)) 0 0 0 nil nil)
schCreateWireLabel(cv nil '(10.376 26.750) "GIOH" "lowerRight" "R90" "stick" 0.0625 nil)
dbCreateInst(cv pddw16sdgz_v_gMaster "RST_top5" '(13.6875 28.0) "R180")
schCreateWire(cv "route" "full" '((13.562 27.000) (13.562 26.250)) 0 0 0 nil nil)
schCreateWireLabel(cv nil '(13.562 26.750) "GIOL" "lowerRight" "R90" "stick" 0.0625 nil)
schCreateWire(cv "route" "full" '((13.438 27.000) (13.438 26.250)) 0 0 0 nil nil)
schCreateWireLabel(cv nil '(13.438 26.750) "RST_CORE" "lowerRight" "R90" "stick" 0.0625 nil)
schCreatePin(cv nil "RST_CORE" "inputOutput" nil '(13.438 26.250) "R90")
schCreateWire(cv "route" "full" '((13.812 27.000) (13.812 26.250)) 0 0 0 nil nil)
schCreateWireLabel(cv nil '(13.812 26.750) "VIOL" "lowerRight" "R90" "stick" 0.0625 nil)
schCreateWire(cv "route" "full" '((13.938 27.000) (13.938 26.250)) 0 0 0 nil nil)
schCreateWireLabel(cv nil '(13.938 26.750) "GIOL" "lowerRight" "R90" "stick" 0.0625 nil)
schCreateWire(cv "route" "full" '((12.999 28.000) (12.999 28.750)) 0 0 0 nil nil)
schCreateWireLabel(cv nil '(12.999 28.250) "RST" "lowerLeft" "R90" "stick" 0.0625 nil)
schCreatePin(cv nil "RST" "inputOutput" nil '(12.999 28.750) "R270")
schCreateWire(cv "route" "full" '((13.312 27.000) (13.312 26.250)) 0 0 0 nil nil)
schCreateWireLabel(cv nil '(13.312 26.750) "POC" "lowerRight" "R90" "stick" 0.0625 nil)
schCreateWire(cv "route" "full" '((13.126 27.000) (13.126 26.250)) 0 0 0 nil nil)
schCreateWireLabel(cv nil '(13.126 26.750) "VIOL" "lowerRight" "R90" "stick" 0.0625 nil)
schCreateWire(cv "route" "full" '((12.938 27.000) (12.938 26.250)) 0 0 0 nil nil)
schCreateWireLabel(cv nil '(12.938 26.750) "GIOL" "lowerRight" "R90" "stick" 0.0625 nil)
schCreateWire(cv "route" "full" '((12.749 27.000) (12.749 26.250)) 0 0 0 nil nil)
schCreateWireLabel(cv nil '(12.749 26.750) "VIOH" "lowerRight" "R90" "stick" 0.0625 nil)
schCreateWire(cv "route" "full" '((12.376 27.000) (12.376 26.250)) 0 0 0 nil nil)
schCreateWireLabel(cv nil '(12.376 26.750) "GIOH" "lowerRight" "R90" "stick" 0.0625 nil)
dbCreateInst(cv pddw16sdgz_v_gMaster "SDO_top6" '(15.6875 28.0) "R180")
schCreateWire(cv "route" "full" '((15.562 27.000) (15.562 26.250)) 0 0 0 nil nil)
schCreateWireLabel(cv nil '(15.562 26.750) "VIOL" "lowerRight" "R90" "stick" 0.0625 nil)
schCreateWire(cv "route" "full" '((15.438 27.000) (15.438 26.250)) 0 0 0 nil nil)
dbCreateInst(cv noConnMaster "noConn_SDO_top6_C" '(15.438 26.250) "R0")
schCreateWire(cv "route" "full" '((15.812 27.000) (15.812 26.250)) 0 0 0 nil nil)
schCreateWireLabel(cv nil '(15.812 26.750) "GIOL" "lowerRight" "R90" "stick" 0.0625 nil)
schCreateWire(cv "route" "full" '((15.938 27.000) (15.938 26.250)) 0 0 0 nil nil)
schCreateWireLabel(cv nil '(15.938 26.750) "SDO_CORE" "lowerRight" "R90" "stick" 0.0625 nil)
schCreatePin(cv nil "SDO_CORE" "inputOutput" nil '(15.938 26.250) "R90")
schCreateWire(cv "route" "full" '((14.999 28.000) (14.999 28.750)) 0 0 0 nil nil)
schCreateWireLabel(cv nil '(14.999 28.250) "SDO" "lowerLeft" "R90" "stick" 0.0625 nil)
schCreatePin(cv nil "SDO" "inputOutput" nil '(14.999 28.750) "R270")
schCreateWire(cv "route" "full" '((15.312 27.000) (15.312 26.250)) 0 0 0 nil nil)
schCreateWireLabel(cv nil '(15.312 26.750) "POC" "lowerRight" "R90" "stick" 0.0625 nil)
schCreateWire(cv "route" "full" '((15.126 27.000) (15.126 26.250)) 0 0 0 nil nil)
schCreateWireLabel(cv nil '(15.126 26.750) "VIOL" "lowerRight" "R90" "stick" 0.0625 nil)
schCreateWire(cv "route" "full" '((14.938 27.000) (14.938 26.250)) 0 0 0 nil nil)
schCreateWireLabel(cv nil '(14.938 26.750) "GIOL" "lowerRight" "R90" "stick" 0.0625 nil)
schCreateWire(cv "route" "full" '((14.749 27.000) (14.749 26.250)) 0 0 0 nil nil)
schCreateWireLabel(cv nil '(14.749 26.750) "VIOH" "lowerRight" "R90" "stick" 0.0625 nil)
schCreateWire(cv "route" "full" '((14.376 27.000) (14.376 26.250)) 0 0 0 nil nil)
schCreateWireLabel(cv nil '(14.376 26.750) "GIOH" "lowerRight" "R90" "stick" 0.0625 nil)
dbCreateInst(cv pddw16sdgz_v_gMaster "SCK_top7" '(17.6875 28.0) "R180")
schCreateWire(cv "route" "full" '((17.562 27.000) (17.562 26.250)) 0 0 0 nil nil)
schCreateWireLabel(cv nil '(17.562 26.750) "GIOL" "lowerRight" "R90" "stick" 0.0625 nil)
schCreateWire(cv "route" "full" '((17.438 27.000) (17.438 26.250)) 0 0 0 nil nil)
schCreateWireLabel(cv nil '(17.438 26.750) "SCK_CORE" "lowerRight" "R90" "stick" 0.0625 nil)
schCreatePin(cv nil "SCK_CORE" "inputOutput" nil '(17.438 26.250) "R90")
schCreateWire(cv "route" "full" '((17.812 27.000) (17.812 26.250)) 0 0 0 nil nil)
schCreateWireLabel(cv nil '(17.812 26.750) "VIOL" "lowerRight" "R90" "stick" 0.0625 nil)
schCreateWire(cv "route" "full" '((17.938 27.000) (17.938 26.250)) 0 0 0 nil nil)
schCreateWireLabel(cv nil '(17.938 26.750) "GIOL" "lowerRight" "R90" "stick" 0.0625 nil)
schCreateWire(cv "route" "full" '((17.000 28.000) (17.000 28.750)) 0 0 0 nil nil)
schCreateWireLabel(cv nil '(17.000 28.250) "SCK" "lowerLeft" "R90" "stick" 0.0625 nil)
schCreatePin(cv nil "SCK" "inputOutput" nil '(17.000 28.750) "R270")
schCreateWire(cv "route" "full" '((17.312 27.000) (17.312 26.250)) 0 0 0 nil nil)
schCreateWireLabel(cv nil '(17.312 26.750) "POC" "lowerRight" "R90" "stick" 0.0625 nil)
schCreateWire(cv "route" "full" '((17.125 27.000) (17.125 26.250)) 0 0 0 nil nil)
schCreateWireLabel(cv nil '(17.125 26.750) "VIOL" "lowerRight" "R90" "stick" 0.0625 nil)
schCreateWire(cv "route" "full" '((16.938 27.000) (16.938 26.250)) 0 0 0 nil nil)
schCreateWireLabel(cv nil '(16.938 26.750) "GIOL" "lowerRight" "R90" "stick" 0.0625 nil)
schCreateWire(cv "route" "full" '((16.750 27.000) (16.750 26.250)) 0 0 0 nil nil)
schCreateWireLabel(cv nil '(16.750 26.750) "VIOH" "lowerRight" "R90" "stick" 0.0625 nil)
schCreateWire(cv "route" "full" '((16.375 27.000) (16.375 26.250)) 0 0 0 nil nil)
schCreateWireLabel(cv nil '(16.375 26.750) "GIOH" "lowerRight" "R90" "stick" 0.0625 nil)
dbCreateInst(cv pddw16sdgz_v_gMaster "SDI_top8" '(19.6875 28.0) "R180")
schCreateWire(cv "route" "full" '((19.562 27.000) (19.562 26.250)) 0 0 0 nil nil)
schCreateWireLabel(cv nil '(19.562 26.750) "GIOL" "lowerRight" "R90" "stick" 0.0625 nil)
schCreateWire(cv "route" "full" '((19.438 27.000) (19.438 26.250)) 0 0 0 nil nil)
schCreateWireLabel(cv nil '(19.438 26.750) "SDI_CORE" "lowerRight" "R90" "stick" 0.0625 nil)
schCreatePin(cv nil "SDI_CORE" "inputOutput" nil '(19.438 26.250) "R90")
schCreateWire(cv "route" "full" '((19.812 27.000) (19.812 26.250)) 0 0 0 nil nil)
schCreateWireLabel(cv nil '(19.812 26.750) "VIOL" "lowerRight" "R90" "stick" 0.0625 nil)
schCreateWire(cv "route" "full" '((19.938 27.000) (19.938 26.250)) 0 0 0 nil nil)
schCreateWireLabel(cv nil '(19.938 26.750) "GIOL" "lowerRight" "R90" "stick" 0.0625 nil)
schCreateWire(cv "route" "full" '((19.000 28.000) (19.000 28.750)) 0 0 0 nil nil)
schCreateWireLabel(cv nil '(19.000 28.250) "SDI" "lowerLeft" "R90" "stick" 0.0625 nil)
schCreatePin(cv nil "SDI" "inputOutput" nil '(19.000 28.750) "R270")
schCreateWire(cv "route" "full" '((19.312 27.000) (19.312 26.250)) 0 0 0 nil nil)
schCreateWireLabel(cv nil '(19.312 26.750) "POC" "lowerRight" "R90" "stick" 0.0625 nil)
schCreateWire(cv "route" "full" '((19.125 27.000) (19.125 26.250)) 0 0 0 nil nil)
schCreateWireLabel(cv nil '(19.125 26.750) "VIOL" "lowerRight" "R90" "stick" 0.0625 nil)
schCreateWire(cv "route" "full" '((18.938 27.000) (18.938 26.250)) 0 0 0 nil nil)
schCreateWireLabel(cv nil '(18.938 26.750) "GIOL" "lowerRight" "R90" "stick" 0.0625 nil)
schCreateWire(cv "route" "full" '((18.750 27.000) (18.750 26.250)) 0 0 0 nil nil)
schCreateWireLabel(cv nil '(18.750 26.750) "VIOH" "lowerRight" "R90" "stick" 0.0625 nil)
schCreateWire(cv "route" "full" '((18.375 27.000) (18.375 26.250)) 0 0 0 nil nil)
schCreateWireLabel(cv nil '(18.375 26.750) "GIOH" "lowerRight" "R90" "stick" 0.0625 nil)
dbCreateInst(cv pddw16sdgz_v_gMaster "SLP_top9" '(21.6875 28.0) "R180")
schCreateWire(cv "route" "full" '((21.562 27.000) (21.562 26.250)) 0 0 0 nil nil)
schCreateWireLabel(cv nil '(21.562 26.750) "GIOL" "lowerRight" "R90" "stick" 0.0625 nil)
schCreateWire(cv "route" "full" '((21.438 27.000) (21.438 26.250)) 0 0 0 nil nil)
schCreateWireLabel(cv nil '(21.438 26.750) "SLP_CORE" "lowerRight" "R90" "stick" 0.0625 nil)
schCreatePin(cv nil "SLP_CORE" "inputOutput" nil '(21.438 26.250) "R90")
schCreateWire(cv "route" "full" '((21.812 27.000) (21.812 26.250)) 0 0 0 nil nil)
schCreateWireLabel(cv nil '(21.812 26.750) "VIOL" "lowerRight" "R90" "stick" 0.0625 nil)
schCreateWire(cv "route" "full" '((21.938 27.000) (21.938 26.250)) 0 0 0 nil nil)
schCreateWireLabel(cv nil '(21.938 26.750) "GIOL" "lowerRight" "R90" "stick" 0.0625 nil)
schCreateWire(cv "route" "full" '((21.000 28.000) (21.000 28.750)) 0 0 0 nil nil)
schCreateWireLabel(cv nil '(21.000 28.250) "SLP" "lowerLeft" "R90" "stick" 0.0625 nil)
schCreatePin(cv nil "SLP" "inputOutput" nil '(21.000 28.750) "R270")
schCreateWire(cv "route" "full" '((21.312 27.000) (21.312 26.250)) 0 0 0 nil nil)
schCreateWireLabel(cv nil '(21.312 26.750) "POC" "lowerRight" "R90" "stick" 0.0625 nil)
schCreateWire(cv "route" "full" '((21.125 27.000) (21.125 26.250)) 0 0 0 nil nil)
schCreateWireLabel(cv nil '(21.125 26.750) "VIOL" "lowerRight" "R90" "stick" 0.0625 nil)
schCreateWire(cv "route" "full" '((20.938 27.000) (20.938 26.250)) 0 0 0 nil nil)
schCreateWireLabel(cv nil '(20.938 26.750) "GIOL" "lowerRight" "R90" "stick" 0.0625 nil)
schCreateWire(cv "route" "full" '((20.750 27.000) (20.750 26.250)) 0 0 0 nil nil)
schCreateWireLabel(cv nil '(20.750 26.750) "VIOH" "lowerRight" "R90" "stick" 0.0625 nil)
schCreateWire(cv "route" "full" '((20.375 27.000) (20.375 26.250)) 0 0 0 nil nil)
schCreateWireLabel(cv nil '(20.375 26.750) "GIOH" "lowerRight" "R90" "stick" 0.0625 nil)
pdb3ac_v_gMaster = dbOpenCellView("tphn28hpcpgv18" "PDB3AC_V_G" "symbol")
dbCreateInst(cv pdb3ac_v_gMaster "VREFDES2_top10" '(22.8125 28.0) "R180")
schCreateWire(cv "route" "full" '((23.000 28.000) (23.000 28.750)) 0 0 0 nil nil)
schCreateWireLabel(cv nil '(23.000 28.250) "VREFDES2" "lowerLeft" "R90" "stick" 0.0625 nil)
schCreatePin(cv nil "VREFDES2" "inputOutput" nil '(23.000 28.750) "R270")
schCreateWire(cv "route" "full" '((23.062 27.125) (23.062 26.375)) 0 0 0 nil nil)
schCreateWireLabel(cv nil '(23.062 26.875) "VREFN" "lowerRight" "R90" "stick" 0.0625 nil)
schCreateWire(cv "route" "full" '((22.688 27.125) (22.688 26.375)) 0 0 0 nil nil)
schCreateWireLabel(cv nil '(22.688 26.875) "GIOL" "lowerRight" "R90" "stick" 0.0625 nil)
schCreateWire(cv "route" "full" '((23.438 27.125) (23.438 26.375)) 0 0 0 nil nil)
schCreateWireLabel(cv nil '(23.438 26.875) "VREFH" "lowerRight" "R90" "stick" 0.0625 nil)
dbCreateInst(cv pdb3ac_v_gMaster "IBREF2_top11" '(24.8125 28.0) "R180")
schCreateWire(cv "route" "full" '((25.000 28.000) (25.000 28.750)) 0 0 0 nil nil)
schCreateWireLabel(cv nil '(25.000 28.250) "IBREF2" "lowerLeft" "R90" "stick" 0.0625 nil)
schCreatePin(cv nil "IBREF2" "inputOutput" nil '(25.000 28.750) "R270")
schCreateWire(cv "route" "full" '((25.062 27.125) (25.062 26.375)) 0 0 0 nil nil)
schCreateWireLabel(cv nil '(25.062 26.875) "VREFN" "lowerRight" "R90" "stick" 0.0625 nil)
schCreateWire(cv "route" "full" '((24.688 27.125) (24.688 26.375)) 0 0 0 nil nil)
schCreateWireLabel(cv nil '(24.688 26.875) "GIOL" "lowerRight" "R90" "stick" 0.0625 nil)
schCreateWire(cv "route" "full" '((25.438 27.125) (25.438 26.375)) 0 0 0 nil nil)
schCreateWireLabel(cv nil '(25.438 26.875) "VREFH" "lowerRight" "R90" "stick" 0.0625 nil)
pvss3a_h_gMaster = dbOpenCellView("tphn28hpcpgv18" "PVSS3A_H_G" "symbol")
dbCreateInst(cv pvss3a_h_gMaster "VREFN_right0" '(28.0 25.1875) "R90")
schCreateWire(cv "route" "full" '((28.000 25.000) (28.750 25.000)) 0 0 0 nil nil)
schCreateWireLabel(cv nil '(28.250 25.000) "VREFN" "lowerLeft" "R0" "stick" 0.0625 nil)
schCreatePin(cv nil "VREFN" "inputOutput" nil '(28.750 25.000) "R180")
schCreateWire(cv "route" "full" '((27.125 24.938) (26.375 24.938)) 0 0 0 nil nil)
schCreateWireLabel(cv nil '(26.875 24.938) "VREFH" "lowerRight" "R0" "stick" 0.0625 nil)
schCreateWire(cv "route" "full" '((27.125 25.312) (26.375 25.312)) 0 0 0 nil nil)
schCreateWireLabel(cv nil '(26.875 25.312) "GIOL" "lowerRight" "R0" "stick" 0.0625 nil)
schCreateWire(cv "route" "full" '((27.125 24.562) (26.375 24.562)) 0 0 0 nil nil)
schCreateWireLabel(cv nil '(26.875 24.562) "VREFN_CORE" "lowerRight" "R0" "stick" 0.0625 nil)
schCreatePin(cv nil "VREFN_CORE" "inputOutput" nil '(26.375 24.562) "R0")
pdb3ac_h_gMaster = dbOpenCellView("tphn28hpcpgv18" "PDB3AC_H_G" "symbol")
dbCreateInst(cv pdb3ac_h_gMaster "VREFM_right1" '(28.0 23.1875) "R90")
schCreateWire(cv "route" "full" '((28.000 23.000) (28.750 23.000)) 0 0 0 nil nil)
schCreateWireLabel(cv nil '(28.250 23.000) "VREFM" "lowerLeft" "R0" "stick" 0.0625 nil)
schCreatePin(cv nil "VREFM" "inputOutput" nil '(28.750 23.000) "R180")
schCreateWire(cv "route" "full" '((27.125 22.938) (26.375 22.938)) 0 0 0 nil nil)
schCreateWireLabel(cv nil '(26.875 22.938) "VREFN" "lowerRight" "R0" "stick" 0.0625 nil)
schCreateWire(cv "route" "full" '((27.125 23.312) (26.375 23.312)) 0 0 0 nil nil)
schCreateWireLabel(cv nil '(26.875 23.312) "GIOL" "lowerRight" "R0" "stick" 0.0625 nil)
schCreateWire(cv "route" "full" '((27.125 22.562) (26.375 22.562)) 0 0 0 nil nil)
schCreateWireLabel(cv nil '(26.875 22.562) "VREFH" "lowerRight" "R0" "stick" 0.0625 nil)
pvdd3a_h_gMaster = dbOpenCellView("tphn28hpcpgv18" "PVDD3A_H_G" "symbol")
dbCreateInst(cv pvdd3a_h_gMaster "VREFH_right2" '(28.0 21.1875) "R90")
schCreateWire(cv "route" "full" '((27.125 20.562) (26.375 20.562)) 0 0 0 nil nil)
schCreateWireLabel(cv nil '(26.875 20.562) "VREFH_CORE" "lowerRight" "R0" "stick" 0.0625 nil)
schCreatePin(cv nil "VREFH_CORE" "inputOutput" nil '(26.375 20.562) "R0")
schCreateWire(cv "route" "full" '((27.125 21.312) (26.375 21.312)) 0 0 0 nil nil)
schCreateWireLabel(cv nil '(26.875 21.312) "GIOL" "lowerRight" "R0" "stick" 0.0625 nil)
schCreateWire(cv "route" "full" '((28.000 21.000) (28.750 21.000)) 0 0 0 nil nil)
schCreateWireLabel(cv nil '(28.250 21.000) "VREFH" "lowerLeft" "R0" "stick" 0.0625 nil)
schCreatePin(cv nil "VREFH" "inputOutput" nil '(28.750 21.000) "R180")
schCreateWire(cv "route" "full" '((27.125 20.938) (26.375 20.938)) 0 0 0 nil nil)
schCreateWireLabel(cv nil '(26.875 20.938) "VREFN" "lowerRight" "R0" "stick" 0.0625 nil)
pvss1ac_h_gMaster = dbOpenCellView("tphn28hpcpgv18" "PVSS1AC_H_G" "symbol")
dbCreateInst(cv pvss1ac_h_gMaster "VSSSAR_right3" '(28.0 19.1875) "R90")
schCreateWire(cv "route" "full" '((28.000 19.000) (28.750 19.000)) 0 0 0 nil nil)
schCreateWireLabel(cv nil '(28.250 19.000) "VSSSAR" "lowerLeft" "R0" "stick" 0.0625 nil)
schCreatePin(cv nil "VSSSAR" "inputOutput" nil '(28.750 19.000) "R180")
schCreateWire(cv "route" "full" '((27.125 18.938) (26.375 18.938)) 0 0 0 nil nil)
schCreateWireLabel(cv nil '(26.875 18.938) "GND_DAT" "lowerRight" "R0" "stick" 0.0625 nil)
schCreateWire(cv "route" "full" '((27.125 19.312) (26.375 19.312)) 0 0 0 nil nil)
schCreateWireLabel(cv nil '(26.875 19.312) "GIOL" "lowerRight" "R0" "stick" 0.0625 nil)
schCreateWire(cv "route" "full" '((27.125 18.562) (26.375 18.562)) 0 0 0 nil nil)
schCreateWireLabel(cv nil '(26.875 18.562) "VDD_DAT" "lowerRight" "R0" "stick" 0.0625 nil)
pvdd1ac_h_gMaster = dbOpenCellView("tphn28hpcpgv18" "PVDD1AC_H_G" "symbol")
dbCreateInst(cv pvdd1ac_h_gMaster "VDDSAR_right4" '(28.0 17.1875) "R90")
schCreateWire(cv "route" "full" '((27.125 16.938) (26.375 16.938)) 0 0 0 nil nil)
schCreateWireLabel(cv nil '(26.875 16.938) "GND_DAT" "lowerRight" "R0" "stick" 0.0625 nil)
schCreateWire(cv "route" "full" '((27.125 17.312) (26.375 17.312)) 0 0 0 nil nil)
schCreateWireLabel(cv nil '(26.875 17.312) "GIOL" "lowerRight" "R0" "stick" 0.0625 nil)
schCreateWire(cv "route" "full" '((28.000 17.000) (28.750 17.000)) 0 0 0 nil nil)
schCreateWireLabel(cv nil '(28.250 17.000) "VDDSAR" "lowerLeft" "R0" "stick" 0.0625 nil)
schCreatePin(cv nil "VDDSAR" "inputOutput" nil '(28.750 17.000) "R180")
schCreateWire(cv "route" "full" '((27.125 16.562) (26.375 16.562)) 0 0 0 nil nil)
schCreateWireLabel(cv nil '(26.875 16.562) "VDD_DAT" "lowerRight" "R0" "stick" 0.0625 nil)
dbCreateInst(cv pvdd1ac_h_gMaster "VDDCLK_right5" '(28.0 15.1875) "R90")
schCreateWire(cv "route" "full" '((27.125 14.938) (26.375 14.938)) 0 0 0 nil nil)
schCreateWireLabel(cv nil '(26.875 14.938) "GND_DAT" "lowerRight" "R0" "stick" 0.0625 nil)
schCreateWire(cv "route" "full" '((27.125 15.312) (26.375 15.312)) 0 0 0 nil nil)
schCreateWireLabel(cv nil '(26.875 15.312) "GIOL" "lowerRight" "R0" "stick" 0.0625 nil)
schCreateWire(cv "route" "full" '((28.000 14.999) (28.750 14.999)) 0 0 0 nil nil)
schCreateWireLabel(cv nil '(28.250 14.999) "VDDCLK" "lowerLeft" "R0" "stick" 0.0625 nil)
schCreatePin(cv nil "VDDCLK" "inputOutput" nil '(28.750 14.999) "R180")
schCreateWire(cv "route" "full" '((27.125 14.562) (26.375 14.562)) 0 0 0 nil nil)
schCreateWireLabel(cv nil '(26.875 14.562) "VDD_DAT" "lowerRight" "R0" "stick" 0.0625 nil)
dbCreateInst(cv pvss1ac_h_gMaster "VSSCLK_right6" '(28.0 13.1875) "R90")
schCreateWire(cv "route" "full" '((28.000 12.999) (28.750 12.999)) 0 0 0 nil nil)
schCreateWireLabel(cv nil '(28.250 12.999) "VSSCLK" "lowerLeft" "R0" "stick" 0.0625 nil)
schCreatePin(cv nil "VSSCLK" "inputOutput" nil '(28.750 12.999) "R180")
schCreateWire(cv "route" "full" '((27.125 12.938) (26.375 12.938)) 0 0 0 nil nil)
schCreateWireLabel(cv nil '(26.875 12.938) "GND_DAT" "lowerRight" "R0" "stick" 0.0625 nil)
schCreateWire(cv "route" "full" '((27.125 13.312) (26.375 13.312)) 0 0 0 nil nil)
schCreateWireLabel(cv nil '(26.875 13.312) "GIOL" "lowerRight" "R0" "stick" 0.0625 nil)
schCreateWire(cv "route" "full" '((27.125 12.562) (26.375 12.562)) 0 0 0 nil nil)
schCreateWireLabel(cv nil '(26.875 12.562) "VDD_DAT" "lowerRight" "R0" "stick" 0.0625 nil)
dbCreateInst(cv pdb3ac_h_gMaster "VCM_right7" '(28.0 11.1875) "R90")
schCreateWire(cv "route" "full" '((28.000 10.999) (28.750 10.999)) 0 0 0 nil nil)
schCreateWireLabel(cv nil '(28.250 10.999) "VCM" "lowerLeft" "R0" "stick" 0.0625 nil)
schCreatePin(cv nil "VCM" "inputOutput" nil '(28.750 10.999) "R180")
schCreateWire(cv "route" "full" '((27.125 10.938) (26.375 10.938)) 0 0 0 nil nil)
schCreateWireLabel(cv nil '(26.875 10.938) "GND_DAT" "lowerRight" "R0" "stick" 0.0625 nil)
schCreateWire(cv "route" "full" '((27.125 11.312) (26.375 11.312)) 0 0 0 nil nil)
schCreateWireLabel(cv nil '(26.875 11.312) "GIOL" "lowerRight" "R0" "stick" 0.0625 nil)
schCreateWire(cv "route" "full" '((27.125 10.562) (26.375 10.562)) 0 0 0 nil nil)
schCreateWireLabel(cv nil '(26.875 10.562) "VDD_DAT" "lowerRight" "R0" "stick" 0.0625 nil)
dbCreateInst(cv pvdd3a_h_gMaster "VDD_DAT_right8" '(28.0 9.1875) "R90")
schCreateWire(cv "route" "full" '((27.125 8.562) (26.375 8.562)) 0 0 0 nil nil)
schCreateWireLabel(cv nil '(26.875 8.562) "VDD_DAT_CORE" "lowerRight" "R0" "stick" 0.0625 nil)
schCreatePin(cv nil "VDD_DAT_CORE" "inputOutput" nil '(26.375 8.562) "R0")
schCreateWire(cv "route" "full" '((27.125 9.312) (26.375 9.312)) 0 0 0 nil nil)
schCreateWireLabel(cv nil '(26.875 9.312) "GIOL" "lowerRight" "R0" "stick" 0.0625 nil)
schCreateWire(cv "route" "full" '((28.000 8.999) (28.750 8.999)) 0 0 0 nil nil)
schCreateWireLabel(cv nil '(28.250 8.999) "VDD_DAT" "lowerLeft" "R0" "stick" 0.0625 nil)
schCreatePin(cv nil "VDD_DAT" "inputOutput" nil '(28.750 8.999) "R180")
schCreateWire(cv "route" "full" '((27.125 8.938) (26.375 8.938)) 0 0 0 nil nil)
schCreateWireLabel(cv nil '(26.875 8.938) "GND_DAT" "lowerRight" "R0" "stick" 0.0625 nil)
dbCreateInst(cv pvss3a_h_gMaster "GND_DAT_right9" '(28.0 7.1875) "R90")
schCreateWire(cv "route" "full" '((28.000 7.000) (28.750 7.000)) 0 0 0 nil nil)
schCreateWireLabel(cv nil '(28.250 7.000) "GND_DAT" "lowerLeft" "R0" "stick" 0.0625 nil)
schCreatePin(cv nil "GND_DAT" "inputOutput" nil '(28.750 7.000) "R180")
schCreateWire(cv "route" "full" '((27.125 6.938) (26.375 6.938)) 0 0 0 nil nil)
schCreateWireLabel(cv nil '(26.875 6.938) "VDD_DAT" "lowerRight" "R0" "stick" 0.0625 nil)
schCreateWire(cv "route" "full" '((27.125 7.312) (26.375 7.312)) 0 0 0 nil nil)
schCreateWireLabel(cv nil '(26.875 7.312) "GIOL" "lowerRight" "R0" "stick" 0.0625 nil)
schCreateWire(cv "route" "full" '((27.125 6.562) (26.375 6.562)) 0 0 0 nil nil)
schCreateWireLabel(cv nil '(26.875 6.562) "GND_DAT_CORE" "lowerRight" "R0" "stick" 0.0625 nil)
schCreatePin(cv nil "GND_DAT_CORE" "inputOutput" nil '(26.375 6.562) "R0")
dbCreateInst(cv pdb3ac_h_gMaster "CLKN_right10" '(28.0 5.1875) "R90")
schCreateWire(cv "route" "full" '((28.000 5.000) (28.750 5.000)) 0 0 0 nil nil)
schCreateWireLabel(cv nil '(28.250 5.000) "CLKN" "lowerLeft" "R0" "stick" 0.0625 nil)
schCreatePin(cv nil "CLKN" "inputOutput" nil '(28.750 5.000) "R180")
schCreateWire(cv "route" "full" '((27.125 4.938) (26.375 4.938)) 0 0 0 nil nil)
schCreateWireLabel(cv nil '(26.875 4.938) "GND_CKB" "lowerRight" "R0" "stick" 0.0625 nil)
schCreateWire(cv "route" "full" '((27.125 5.312) (26.375 5.312)) 0 0 0 nil nil)
schCreateWireLabel(cv nil '(26.875 5.312) "GIOL" "lowerRight" "R0" "stick" 0.0625 nil)
schCreateWire(cv "route" "full" '((27.125 4.562) (26.375 4.562)) 0 0 0 nil nil)
schCreateWireLabel(cv nil '(26.875 4.562) "VDD_CKB" "lowerRight" "R0" "stick" 0.0625 nil)
dbCreateInst(cv pdb3ac_h_gMaster "CLKP_right11" '(28.0 3.1875) "R90")
schCreateWire(cv "route" "full" '((28.000 2.999) (28.750 2.999)) 0 0 0 nil nil)
schCreateWireLabel(cv nil '(28.250 2.999) "CLKP" "lowerLeft" "R0" "stick" 0.0625 nil)
schCreatePin(cv nil "CLKP" "inputOutput" nil '(28.750 2.999) "R180")
schCreateWire(cv "route" "full" '((27.125 2.938) (26.375 2.938)) 0 0 0 nil nil)
schCreateWireLabel(cv nil '(26.875 2.938) "GND_CKB" "lowerRight" "R0" "stick" 0.0625 nil)
schCreateWire(cv "route" "full" '((27.125 3.312) (26.375 3.312)) 0 0 0 nil nil)
schCreateWireLabel(cv nil '(26.875 3.312) "GIOL" "lowerRight" "R0" "stick" 0.0625 nil)
schCreateWire(cv "route" "full" '((27.125 2.562) (26.375 2.562)) 0 0 0 nil nil)
schCreateWireLabel(cv nil '(26.875 2.562) "VDD_CKB" "lowerRight" "R0" "stick" 0.0625 nil)
pvss3a_v_gMaster = dbOpenCellView("tphn28hpcpgv18" "PVSS3A_V_G" "symbol")
dbCreateInst(cv pvss3a_v_gMaster "GND_CKB_bottom0" '(25.1875 0) "R0")
schCreateWire(cv "route" "full" '((25.000 0.000) (25.000 -0.750)) 0 0 0 nil nil)
schCreateWireLabel(cv nil '(25.000 -0.250) "GND_CKB" "lowerRight" "R90" "stick" 0.0625 nil)
schCreatePin(cv nil "GND_CKB" "inputOutput" nil '(25.000 -0.750) "R90")
schCreateWire(cv "route" "full" '((24.938 0.875) (24.938 1.625)) 0 0 0 nil nil)
schCreateWireLabel(cv nil '(24.938 1.125) "VDD_CKB" "lowerLeft" "R90" "stick" 0.0625 nil)
schCreateWire(cv "route" "full" '((25.312 0.875) (25.312 1.625)) 0 0 0 nil nil)
schCreateWireLabel(cv nil '(25.312 1.125) "GIOL" "lowerLeft" "R90" "stick" 0.0625 nil)
schCreateWire(cv "route" "full" '((24.562 0.875) (24.562 1.625)) 0 0 0 nil nil)
schCreateWireLabel(cv nil '(24.562 1.125) "GND_CKB_CORE" "lowerLeft" "R90" "stick" 0.0625 nil)
schCreatePin(cv nil "GND_CKB_CORE" "inputOutput" nil '(24.562 1.625) "R270")
pvdd3a_v_gMaster = dbOpenCellView("tphn28hpcpgv18" "PVDD3A_V_G" "symbol")
dbCreateInst(cv pvdd3a_v_gMaster "VDD_CKB_bottom1" '(23.1875 0) "R0")
schCreateWire(cv "route" "full" '((22.562 0.875) (22.562 1.625)) 0 0 0 nil nil)
schCreateWireLabel(cv nil '(22.562 1.125) "VDD_CKB_CORE" "lowerLeft" "R90" "stick" 0.0625 nil)
schCreatePin(cv nil "VDD_CKB_CORE" "inputOutput" nil '(22.562 1.625) "R270")
schCreateWire(cv "route" "full" '((23.312 0.875) (23.312 1.625)) 0 0 0 nil nil)
schCreateWireLabel(cv nil '(23.312 1.125) "GIOL" "lowerLeft" "R90" "stick" 0.0625 nil)
schCreateWire(cv "route" "full" '((23.000 0.000) (23.000 -0.750)) 0 0 0 nil nil)
schCreateWireLabel(cv nil '(23.000 -0.250) "VDD_CKB" "lowerRight" "R90" "stick" 0.0625 nil)
schCreatePin(cv nil "VDD_CKB" "inputOutput" nil '(23.000 -0.750) "R90")
schCreateWire(cv "route" "full" '((22.938 0.875) (22.938 1.625)) 0 0 0 nil nil)
schCreateWireLabel(cv nil '(22.938 1.125) "GND_CKB" "lowerLeft" "R90" "stick" 0.0625 nil)
dbCreateInst(cv pdb3ac_v_gMaster "VINCM_bottom2" '(21.1875 0) "R0")
schCreateWire(cv "route" "full" '((21.000 0.000) (21.000 -0.750)) 0 0 0 nil nil)
schCreateWireLabel(cv nil '(21.000 -0.250) "VINCM" "lowerRight" "R90" "stick" 0.0625 nil)
schCreatePin(cv nil "VINCM" "inputOutput" nil '(21.000 -0.750) "R90")
schCreateWire(cv "route" "full" '((20.938 0.875) (20.938 1.625)) 0 0 0 nil nil)
schCreateWireLabel(cv nil '(20.938 1.125) "VSSIB" "lowerLeft" "R90" "stick" 0.0625 nil)
schCreateWire(cv "route" "full" '((21.312 0.875) (21.312 1.625)) 0 0 0 nil nil)
schCreateWireLabel(cv nil '(21.312 1.125) "GIOL" "lowerLeft" "R90" "stick" 0.0625 nil)
schCreateWire(cv "route" "full" '((20.562 0.875) (20.562 1.625)) 0 0 0 nil nil)
schCreateWireLabel(cv nil '(20.562 1.125) "VDDIB" "lowerLeft" "R90" "stick" 0.0625 nil)
dbCreateInst(cv pvss3a_v_gMaster "VSSIB_bottom3" '(19.1875 0) "R0")
schCreateWire(cv "route" "full" '((19.000 0.000) (19.000 -0.750)) 0 0 0 nil nil)
schCreateWireLabel(cv nil '(19.000 -0.250) "VSSIB" "lowerRight" "R90" "stick" 0.0625 nil)
schCreatePin(cv nil "VSSIB" "inputOutput" nil '(19.000 -0.750) "R90")
schCreateWire(cv "route" "full" '((18.938 0.875) (18.938 1.625)) 0 0 0 nil nil)
schCreateWireLabel(cv nil '(18.938 1.125) "VDDIB" "lowerLeft" "R90" "stick" 0.0625 nil)
schCreateWire(cv "route" "full" '((19.312 0.875) (19.312 1.625)) 0 0 0 nil nil)
schCreateWireLabel(cv nil '(19.312 1.125) "GIOL" "lowerLeft" "R90" "stick" 0.0625 nil)
schCreateWire(cv "route" "full" '((18.562 0.875) (18.562 1.625)) 0 0 0 nil nil)
schCreateWireLabel(cv nil '(18.562 1.125) "VSSIB_CORE" "lowerLeft" "R90" "stick" 0.0625 nil)
schCreatePin(cv nil "VSSIB_CORE" "inputOutput" nil '(18.562 1.625) "R270")
dbCreateInst(cv pdb3ac_v_gMaster "VINP_bottom4" '(17.1875 0) "R0")
schCreateWire(cv "route" "full" '((17.000 0.000) (17.000 -0.750)) 0 0 0 nil nil)
schCreateWireLabel(cv nil '(17.000 -0.250) "VINP" "lowerRight" "R90" "stick" 0.0625 nil)
schCreatePin(cv nil "VINP" "inputOutput" nil '(17.000 -0.750) "R90")
schCreateWire(cv "route" "full" '((16.938 0.875) (16.938 1.625)) 0 0 0 nil nil)
schCreateWireLabel(cv nil '(16.938 1.125) "VSSIB" "lowerLeft" "R90" "stick" 0.0625 nil)
schCreateWire(cv "route" "full" '((17.312 0.875) (17.312 1.625)) 0 0 0 nil nil)
schCreateWireLabel(cv nil '(17.312 1.125) "GIOL" "lowerLeft" "R90" "stick" 0.0625 nil)
schCreateWire(cv "route" "full" '((16.562 0.875) (16.562 1.625)) 0 0 0 nil nil)
schCreateWireLabel(cv nil '(16.562 1.125) "VDDIB" "lowerLeft" "R90" "stick" 0.0625 nil)
dbCreateInst(cv pdb3ac_v_gMaster "VINN_bottom5" '(15.1875 0) "R0")
schCreateWire(cv "route" "full" '((14.999 0.000) (14.999 -0.750)) 0 0 0 nil nil)
schCreateWireLabel(cv nil '(14.999 -0.250) "VINN" "lowerRight" "R90" "stick" 0.0625 nil)
schCreatePin(cv nil "VINN" "inputOutput" nil '(14.999 -0.750) "R90")
schCreateWire(cv "route" "full" '((14.938 0.875) (14.938 1.625)) 0 0 0 nil nil)
schCreateWireLabel(cv nil '(14.938 1.125) "VSSIB" "lowerLeft" "R90" "stick" 0.0625 nil)
schCreateWire(cv "route" "full" '((15.312 0.875) (15.312 1.625)) 0 0 0 nil nil)
schCreateWireLabel(cv nil '(15.312 1.125) "GIOL" "lowerLeft" "R90" "stick" 0.0625 nil)
schCreateWire(cv "route" "full" '((14.562 0.875) (14.562 1.625)) 0 0 0 nil nil)
schCreateWireLabel(cv nil '(14.562 1.125) "VDDIB" "lowerLeft" "R90" "stick" 0.0625 nil)
dbCreateInst(cv pvss3a_v_gMaster "VSSIB_bottom6" '(13.1875 0) "R0")
schCreateWire(cv "route" "full" '((12.999 0.000) (12.999 -0.750)) 0 0 0 nil nil)
schCreateWireLabel(cv nil '(12.999 -0.250) "VSSIB" "lowerRight" "R90" "stick" 0.0625 nil)
schCreatePin(cv nil "VSSIB" "inputOutput" nil '(12.999 -0.750) "R90")
schCreateWire(cv "route" "full" '((12.938 0.875) (12.938 1.625)) 0 0 0 nil nil)
schCreateWireLabel(cv nil '(12.938 1.125) "VDDIB" "lowerLeft" "R90" "stick" 0.0625 nil)
schCreateWire(cv "route" "full" '((13.312 0.875) (13.312 1.625)) 0 0 0 nil nil)
schCreateWireLabel(cv nil '(13.312 1.125) "GIOL" "lowerLeft" "R90" "stick" 0.0625 nil)
schCreateWire(cv "route" "full" '((12.562 0.875) (12.562 1.625)) 0 0 0 nil nil)
schCreateWireLabel(cv nil '(12.562 1.125) "VSSIB_CORE" "lowerLeft" "R90" "stick" 0.0625 nil)
schCreatePin(cv nil "VSSIB_CORE" "inputOutput" nil '(12.562 1.625) "R270")
dbCreateInst(cv pvdd3a_v_gMaster "VDDIB_bottom7" '(11.1875 0) "R0")
schCreateWire(cv "route" "full" '((10.562 0.875) (10.562 1.625)) 0 0 0 nil nil)
schCreateWireLabel(cv nil '(10.562 1.125) "VDDIB_CORE" "lowerLeft" "R90" "stick" 0.0625 nil)
schCreatePin(cv nil "VDDIB_CORE" "inputOutput" nil '(10.562 1.625) "R270")
schCreateWire(cv "route" "full" '((11.312 0.875) (11.312 1.625)) 0 0 0 nil nil)
schCreateWireLabel(cv nil '(11.312 1.125) "GIOL" "lowerLeft" "R90" "stick" 0.0625 nil)
schCreateWire(cv "route" "full" '((10.999 0.000) (10.999 -0.750)) 0 0 0 nil nil)
schCreateWireLabel(cv nil '(10.999 -0.250) "VDDIB" "lowerRight" "R90" "stick" 0.0625 nil)
schCreatePin(cv nil "VDDIB" "inputOutput" nil '(10.999 -0.750) "R90")
schCreateWire(cv "route" "full" '((10.938 0.875) (10.938 1.625)) 0 0 0 nil nil)
schCreateWireLabel(cv nil '(10.938 1.125) "VSSIB" "lowerLeft" "R90" "stick" 0.0625 nil)
pvss1ac_v_gMaster = dbOpenCellView("tphn28hpcpgv18" "PVSS1AC_V_G" "symbol")
dbCreateInst(cv pvss1ac_v_gMaster "VSS_bottom8" '(9.1875 0) "R0")
schCreateWire(cv "route" "full" '((8.999 0.000) (8.999 -0.750)) 0 0 0 nil nil)
schCreateWireLabel(cv nil '(8.999 -0.250) "VSS" "lowerRight" "R90" "stick" 0.0625 nil)
schCreatePin(cv nil "VSS" "inputOutput" nil '(8.999 -0.750) "R90")
schCreateWire(cv "route" "full" '((8.938 0.875) (8.938 1.625)) 0 0 0 nil nil)
schCreateWireLabel(cv nil '(8.938 1.125) "VSSIB" "lowerLeft" "R90" "stick" 0.0625 nil)
schCreateWire(cv "route" "full" '((9.312 0.875) (9.312 1.625)) 0 0 0 nil nil)
schCreateWireLabel(cv nil '(9.312 1.125) "GIOL" "lowerLeft" "R90" "stick" 0.0625 nil)
schCreateWire(cv "route" "full" '((8.562 0.875) (8.562 1.625)) 0 0 0 nil nil)
schCreateWireLabel(cv nil '(8.562 1.125) "VDDIB" "lowerLeft" "R90" "stick" 0.0625 nil)
dbCreateInst(cv pdb3ac_v_gMaster "IBUF_IBIAS_bottom9" '(7.1875 0) "R0")
schCreateWire(cv "route" "full" '((7.000 0.000) (7.000 -0.750)) 0 0 0 nil nil)
schCreateWireLabel(cv nil '(7.000 -0.250) "IBUF_IBIAS" "lowerRight" "R90" "stick" 0.0625 nil)
schCreatePin(cv nil "IBUF_IBIAS" "inputOutput" nil '(7.000 -0.750) "R90")
schCreateWire(cv "route" "full" '((6.938 0.875) (6.938 1.625)) 0 0 0 nil nil)
schCreateWireLabel(cv nil '(6.938 1.125) "VSSIB" "lowerLeft" "R90" "stick" 0.0625 nil)
schCreateWire(cv "route" "full" '((7.312 0.875) (7.312 1.625)) 0 0 0 nil nil)
schCreateWireLabel(cv nil '(7.312 1.125) "GIOL" "lowerLeft" "R90" "stick" 0.0625 nil)
schCreateWire(cv "route" "full" '((6.562 0.875) (6.562 1.625)) 0 0 0 nil nil)
schCreateWireLabel(cv nil '(6.562 1.125) "VDDIB" "lowerLeft" "R90" "stick" 0.0625 nil)
dbCreateInst(cv pvss1ac_v_gMaster "VSS_bottom10" '(5.1875 0) "R0")
schCreateWire(cv "route" "full" '((5.000 0.000) (5.000 -0.750)) 0 0 0 nil nil)
schCreateWireLabel(cv nil '(5.000 -0.250) "VSS" "lowerRight" "R90" "stick" 0.0625 nil)
schCreatePin(cv nil "VSS" "inputOutput" nil '(5.000 -0.750) "R90")
schCreateWire(cv "route" "full" '((4.938 0.875) (4.938 1.625)) 0 0 0 nil nil)
schCreateWireLabel(cv nil '(4.938 1.125) "VSSIB" "lowerLeft" "R90" "stick" 0.0625 nil)
schCreateWire(cv "route" "full" '((5.312 0.875) (5.312 1.625)) 0 0 0 nil nil)
schCreateWireLabel(cv nil '(5.312 1.125) "GIOL" "lowerLeft" "R90" "stick" 0.0625 nil)
schCreateWire(cv "route" "full" '((4.562 0.875) (4.562 1.625)) 0 0 0 nil nil)
schCreateWireLabel(cv nil '(4.562 1.125) "VDDIB" "lowerLeft" "R90" "stick" 0.0625 nil)
dbCreateInst(cv pdb3ac_v_gMaster "IBREF_bottom11" '(3.1875 0) "R0")
schCreateWire(cv "route" "full" '((2.999 0.000) (2.999 -0.750)) 0 0 0 nil nil)
schCreateWireLabel(cv nil '(2.999 -0.250) "IBREF" "lowerRight" "R90" "stick" 0.0625 nil)
schCreatePin(cv nil "IBREF" "inputOutput" nil '(2.999 -0.750) "R90")
schCreateWire(cv "route" "full" '((2.938 0.875) (2.938 1.625)) 0 0 0 nil nil)
schCreateWireLabel(cv nil '(2.938 1.125) "VSSIB" "lowerLeft" "R90" "stick" 0.0625 nil)
schCreateWire(cv "route" "full" '((3.312 0.875) (3.312 1.625)) 0 0 0 nil nil)
schCreateWireLabel(cv nil '(3.312 1.125) "GIOL" "lowerLeft" "R90" "stick" 0.0625 nil)
schCreateWire(cv "route" "full" '((2.562 0.875) (2.562 1.625)) 0 0 0 nil nil)
schCreateWireLabel(cv nil '(2.562 1.125) "VDDIB" "lowerLeft" "R90" "stick" 0.0625 nil)
dbCreateInst(cv pdb3ac_h_gMaster "VREFDES_left0" '(0 2.8125) "R270")
schCreateWire(cv "route" "full" '((0.000 3.001) (-0.750 3.001)) 0 0 0 nil nil)
schCreateWireLabel(cv nil '(-0.250 3.001) "VREFDES" "lowerRight" "R0" "stick" 0.0625 nil)
schCreatePin(cv nil "VREFDES" "inputOutput" nil '(-0.750 3.001) "R0")
schCreateWire(cv "route" "full" '((0.875 3.062) (1.625 3.062)) 0 0 0 nil nil)
schCreateWireLabel(cv nil '(1.125 3.062) "VSSIB" "lowerLeft" "R0" "stick" 0.0625 nil)
schCreateWire(cv "route" "full" '((0.875 2.688) (1.625 2.688)) 0 0 0 nil nil)
schCreateWireLabel(cv nil '(1.125 2.688) "GIOL" "lowerLeft" "R0" "stick" 0.0625 nil)
schCreateWire(cv "route" "full" '((0.875 3.438) (1.625 3.438)) 0 0 0 nil nil)
schCreateWireLabel(cv nil '(1.125 3.438) "VDDIB" "lowerLeft" "R0" "stick" 0.0625 nil)
dbCreateInst(cv pvdd1ac_h_gMaster "VDD_CDAC_left1" '(0 4.8125) "R270")
schCreateWire(cv "route" "full" '((0.875 5.062) (1.625 5.062)) 0 0 0 nil nil)
schCreateWireLabel(cv nil '(1.125 5.062) "VSSIB" "lowerLeft" "R0" "stick" 0.0625 nil)
schCreateWire(cv "route" "full" '((0.875 4.688) (1.625 4.688)) 0 0 0 nil nil)
schCreateWireLabel(cv nil '(1.125 4.688) "GIOL" "lowerLeft" "R0" "stick" 0.0625 nil)
schCreateWire(cv "route" "full" '((0.000 5.000) (-0.750 5.000)) 0 0 0 nil nil)
schCreateWireLabel(cv nil '(-0.250 5.000) "VDD_CDAC" "lowerRight" "R0" "stick" 0.0625 nil)
schCreatePin(cv nil "VDD_CDAC" "inputOutput" nil '(-0.750 5.000) "R0")
schCreateWire(cv "route" "full" '((0.875 5.438) (1.625 5.438)) 0 0 0 nil nil)
schCreateWireLabel(cv nil '(1.125 5.438) "VDDIB" "lowerLeft" "R0" "stick" 0.0625 nil)
dbCreateInst(cv pdb3ac_h_gMaster "IB12_left2" '(0 6.8125) "R270")
schCreateWire(cv "route" "full" '((0.000 7.000) (-0.750 7.000)) 0 0 0 nil nil)
schCreateWireLabel(cv nil '(-0.250 7.000) "IB12" "lowerRight" "R0" "stick" 0.0625 nil)
schCreatePin(cv nil "IB12" "inputOutput" nil '(-0.750 7.000) "R0")
schCreateWire(cv "route" "full" '((0.875 7.062) (1.625 7.062)) 0 0 0 nil nil)
schCreateWireLabel(cv nil '(1.125 7.062) "VSSIB" "lowerLeft" "R0" "stick" 0.0625 nil)
schCreateWire(cv "route" "full" '((0.875 6.688) (1.625 6.688)) 0 0 0 nil nil)
schCreateWireLabel(cv nil '(1.125 6.688) "GIOL" "lowerLeft" "R0" "stick" 0.0625 nil)
schCreateWire(cv "route" "full" '((0.875 7.438) (1.625 7.438)) 0 0 0 nil nil)
schCreateWireLabel(cv nil '(1.125 7.438) "VDDIB" "lowerLeft" "R0" "stick" 0.0625 nil)
dbCreateInst(cv pvdd1ac_h_gMaster "VDD12_left3" '(0 8.8125) "R270")
schCreateWire(cv "route" "full" '((0.875 9.062) (1.625 9.062)) 0 0 0 nil nil)
schCreateWireLabel(cv nil '(1.125 9.062) "VSSIB" "lowerLeft" "R0" "stick" 0.0625 nil)
schCreateWire(cv "route" "full" '((0.875 8.688) (1.625 8.688)) 0 0 0 nil nil)
schCreateWireLabel(cv nil '(1.125 8.688) "GIOL" "lowerLeft" "R0" "stick" 0.0625 nil)
schCreateWire(cv "route" "full" '((0.000 9.001) (-0.750 9.001)) 0 0 0 nil nil)
schCreateWireLabel(cv nil '(-0.250 9.001) "VDD12" "lowerRight" "R0" "stick" 0.0625 nil)
schCreatePin(cv nil "VDD12" "inputOutput" nil '(-0.750 9.001) "R0")
schCreateWire(cv "route" "full" '((0.875 9.438) (1.625 9.438)) 0 0 0 nil nil)
schCreateWireLabel(cv nil '(1.125 9.438) "VDDIB" "lowerLeft" "R0" "stick" 0.0625 nil)
dbCreateInst(cv pdb3ac_h_gMaster "IB3_left4" '(0 10.8125) "R270")
schCreateWire(cv "route" "full" '((0.000 11.001) (-0.750 11.001)) 0 0 0 nil nil)
schCreateWireLabel(cv nil '(-0.250 11.001) "IB3" "lowerRight" "R0" "stick" 0.0625 nil)
schCreatePin(cv nil "IB3" "inputOutput" nil '(-0.750 11.001) "R0")
schCreateWire(cv "route" "full" '((0.875 11.062) (1.625 11.062)) 0 0 0 nil nil)
schCreateWireLabel(cv nil '(1.125 11.062) "VSSIB" "lowerLeft" "R0" "stick" 0.0625 nil)
schCreateWire(cv "route" "full" '((0.875 10.688) (1.625 10.688)) 0 0 0 nil nil)
schCreateWireLabel(cv nil '(1.125 10.688) "GIOL" "lowerLeft" "R0" "stick" 0.0625 nil)
schCreateWire(cv "route" "full" '((0.875 11.438) (1.625 11.438)) 0 0 0 nil nil)
schCreateWireLabel(cv nil '(1.125 11.438) "VDDIB" "lowerLeft" "R0" "stick" 0.0625 nil)
dbCreateInst(cv pvdd1ac_h_gMaster "VDD3_left5" '(0 12.8125) "R270")
schCreateWire(cv "route" "full" '((0.875 13.062) (1.625 13.062)) 0 0 0 nil nil)
schCreateWireLabel(cv nil '(1.125 13.062) "VSSIB" "lowerLeft" "R0" "stick" 0.0625 nil)
schCreateWire(cv "route" "full" '((0.875 12.688) (1.625 12.688)) 0 0 0 nil nil)
schCreateWireLabel(cv nil '(1.125 12.688) "GIOL" "lowerLeft" "R0" "stick" 0.0625 nil)
schCreateWire(cv "route" "full" '((0.000 13.001) (-0.750 13.001)) 0 0 0 nil nil)
schCreateWireLabel(cv nil '(-0.250 13.001) "VDD3" "lowerRight" "R0" "stick" 0.0625 nil)
schCreatePin(cv nil "VDD3" "inputOutput" nil '(-0.750 13.001) "R0")
schCreateWire(cv "route" "full" '((0.875 13.438) (1.625 13.438)) 0 0 0 nil nil)
schCreateWireLabel(cv nil '(1.125 13.438) "VDDIB" "lowerLeft" "R0" "stick" 0.0625 nil)
pvss1dgz_h_gMaster = dbOpenCellView("tphn28hpcpgv18" "PVSS1DGZ_H_G" "symbol")
dbCreateInst(cv pvss1dgz_h_gMaster "GIOL_left6" '(0 16.0) "R270")
schCreateWire(cv "route" "full" '((1.000 15.625) (1.750 15.625)) 0 0 0 nil nil)
schCreateWireLabel(cv nil '(1.250 15.625) "POC" "lowerLeft" "R0" "stick" 0.0625 nil)
schCreateWire(cv "route" "full" '((1.000 15.438) (1.750 15.438)) 0 0 0 nil nil)
schCreateWireLabel(cv nil '(1.250 15.438) "VIOL" "lowerLeft" "R0" "stick" 0.0625 nil)
schCreateWire(cv "route" "full" '((0.000 15.000) (-0.750 15.000)) 0 0 0 nil nil)
schCreateWireLabel(cv nil '(-0.250 15.000) "GIOL" "lowerRight" "R0" "stick" 0.0625 nil)
schCreatePin(cv nil "GIOL" "inputOutput" nil '(-0.750 15.000) "R0")
schCreateWire(cv "route" "full" '((1.000 15.062) (1.750 15.062)) 0 0 0 nil nil)
schCreateWireLabel(cv nil '(1.250 15.062) "VIOH" "lowerLeft" "R0" "stick" 0.0625 nil)
schCreateWire(cv "route" "full" '((1.000 14.688) (1.750 14.688)) 0 0 0 nil nil)
schCreateWireLabel(cv nil '(1.250 14.688) "GIOH" "lowerLeft" "R0" "stick" 0.0625 nil)
pvdd1dgz_h_gMaster = dbOpenCellView("tphn28hpcpgv18" "PVDD1DGZ_H_G" "symbol")
dbCreateInst(cv pvdd1dgz_h_gMaster "VIOL_left7" '(0 18.0) "R270")
schCreateWire(cv "route" "full" '((1.000 17.625) (1.750 17.625)) 0 0 0 nil nil)
schCreateWireLabel(cv nil '(1.250 17.625) "POC" "lowerLeft" "R0" "stick" 0.0625 nil)
schCreateWire(cv "route" "full" '((0.000 17.000) (-0.750 17.000)) 0 0 0 nil nil)
schCreateWireLabel(cv nil '(-0.250 17.000) "VIOL" "lowerRight" "R0" "stick" 0.0625 nil)
schCreatePin(cv nil "VIOL" "inputOutput" nil '(-0.750 17.000) "R0")
schCreateWire(cv "route" "full" '((1.000 17.250) (1.750 17.250)) 0 0 0 nil nil)
schCreateWireLabel(cv nil '(1.250 17.250) "GIOL" "lowerLeft" "R0" "stick" 0.0625 nil)
schCreateWire(cv "route" "full" '((1.000 17.062) (1.750 17.062)) 0 0 0 nil nil)
schCreateWireLabel(cv nil '(1.250 17.062) "VIOH" "lowerLeft" "R0" "stick" 0.0625 nil)
schCreateWire(cv "route" "full" '((1.000 16.688) (1.750 16.688)) 0 0 0 nil nil)
schCreateWireLabel(cv nil '(1.250 16.688) "GIOH" "lowerLeft" "R0" "stick" 0.0625 nil)
pvss2dgz_h_gMaster = dbOpenCellView("tphn28hpcpgv18" "PVSS2DGZ_H_G" "symbol")
dbCreateInst(cv pvss2dgz_h_gMaster "GIOH_left8" '(0 20.0) "R270")
schCreateWire(cv "route" "full" '((1.000 19.625) (1.750 19.625)) 0 0 0 nil nil)
schCreateWireLabel(cv nil '(1.250 19.625) "POC" "lowerLeft" "R0" "stick" 0.0625 nil)
schCreateWire(cv "route" "full" '((1.000 19.438) (1.750 19.438)) 0 0 0 nil nil)
schCreateWireLabel(cv nil '(1.250 19.438) "VIOL" "lowerLeft" "R0" "stick" 0.0625 nil)
schCreateWire(cv "route" "full" '((1.000 19.250) (1.750 19.250)) 0 0 0 nil nil)
schCreateWireLabel(cv nil '(1.250 19.250) "GIOL" "lowerLeft" "R0" "stick" 0.0625 nil)
schCreateWire(cv "route" "full" '((1.000 19.062) (1.750 19.062)) 0 0 0 nil nil)
schCreateWireLabel(cv nil '(1.250 19.062) "VIOH" "lowerLeft" "R0" "stick" 0.0625 nil)
schCreateWire(cv "route" "full" '((0.000 19.000) (-0.750 19.000)) 0 0 0 nil nil)
schCreateWireLabel(cv nil '(-0.250 19.000) "GIOH" "lowerRight" "R0" "stick" 0.0625 nil)
schCreatePin(cv nil "GIOH" "inputOutput" nil '(-0.750 19.000) "R0")
pvdd2poc_h_gMaster = dbOpenCellView("tphn28hpcpgv18" "PVDD2POC_H_G" "symbol")
dbCreateInst(cv pvdd2poc_h_gMaster "VIOH_left9" '(0 22.0) "R270")
schCreateWire(cv "route" "full" '((1.000 21.625) (1.750 21.625)) 0 0 0 nil nil)
schCreateWireLabel(cv nil '(1.250 21.625) "POC" "lowerLeft" "R0" "stick" 0.0625 nil)
schCreateWire(cv "route" "full" '((1.000 21.438) (1.750 21.438)) 0 0 0 nil nil)
schCreateWireLabel(cv nil '(1.250 21.438) "VIOL" "lowerLeft" "R0" "stick" 0.0625 nil)
schCreateWire(cv "route" "full" '((1.000 21.250) (1.750 21.250)) 0 0 0 nil nil)
schCreateWireLabel(cv nil '(1.250 21.250) "GIOL" "lowerLeft" "R0" "stick" 0.0625 nil)
schCreateWire(cv "route" "full" '((0.000 21.000) (-0.750 21.000)) 0 0 0 nil nil)
schCreateWireLabel(cv nil '(-0.250 21.000) "VIOH" "lowerRight" "R0" "stick" 0.0625 nil)
schCreatePin(cv nil "VIOH" "inputOutput" nil '(-0.750 21.000) "R0")
schCreateWire(cv "route" "full" '((1.000 20.688) (1.750 20.688)) 0 0 0 nil nil)
schCreateWireLabel(cv nil '(1.250 20.688) "GIOH" "lowerLeft" "R0" "stick" 0.0625 nil)
pddw16sdgz_h_gMaster = dbOpenCellView("tphn28hpcpgv18" "PDDW16SDGZ_H_G" "symbol")
dbCreateInst(cv pddw16sdgz_h_gMaster "SYNC_left10" '(0 23.6875) "R270")
schCreateWire(cv "route" "full" '((1.000 23.562) (1.750 23.562)) 0 0 0 nil nil)
schCreateWireLabel(cv nil '(1.250 23.562) "GIOL" "lowerLeft" "R0" "stick" 0.0625 nil)
schCreateWire(cv "route" "full" '((1.000 23.438) (1.750 23.438)) 0 0 0 nil nil)
schCreateWireLabel(cv nil '(1.250 23.438) "SYNC_CORE" "lowerLeft" "R0" "stick" 0.0625 nil)
schCreatePin(cv nil "SYNC_CORE" "inputOutput" nil '(1.750 23.438) "R180")
schCreateWire(cv "route" "full" '((1.000 23.812) (1.750 23.812)) 0 0 0 nil nil)
schCreateWireLabel(cv nil '(1.250 23.812) "VIOL" "lowerLeft" "R0" "stick" 0.0625 nil)
schCreateWire(cv "route" "full" '((1.000 23.938) (1.750 23.938)) 0 0 0 nil nil)
schCreateWireLabel(cv nil '(1.250 23.938) "GIOL" "lowerLeft" "R0" "stick" 0.0625 nil)
schCreateWire(cv "route" "full" '((0.000 23.000) (-0.750 23.000)) 0 0 0 nil nil)
schCreateWireLabel(cv nil '(-0.250 23.000) "SYNC" "lowerRight" "R0" "stick" 0.0625 nil)
schCreatePin(cv nil "SYNC" "inputOutput" nil '(-0.750 23.000) "R0")
schCreateWire(cv "route" "full" '((1.000 23.312) (1.750 23.312)) 0 0 0 nil nil)
schCreateWireLabel(cv nil '(1.250 23.312) "POC" "lowerLeft" "R0" "stick" 0.0625 nil)
schCreateWire(cv "route" "full" '((1.000 23.125) (1.750 23.125)) 0 0 0 nil nil)
schCreateWireLabel(cv nil '(1.250 23.125) "VIOL" "lowerLeft" "R0" "stick" 0.0625 nil)
schCreateWire(cv "route" "full" '((1.000 22.938) (1.750 22.938)) 0 0 0 nil nil)
schCreateWireLabel(cv nil '(1.250 22.938) "GIOL" "lowerLeft" "R0" "stick" 0.0625 nil)
schCreateWire(cv "route" "full" '((1.000 22.750) (1.750 22.750)) 0 0 0 nil nil)
schCreateWireLabel(cv nil '(1.250 22.750) "VIOH" "lowerLeft" "R0" "stick" 0.0625 nil)
schCreateWire(cv "route" "full" '((1.000 22.375) (1.750 22.375)) 0 0 0 nil nil)
schCreateWireLabel(cv nil '(1.250 22.375) "GIOH" "lowerLeft" "R0" "stick" 0.0625 nil)
dbCreateInst(cv pddw16sdgz_h_gMaster "DCLK_left11" '(0 25.6875) "R270")
schCreateWire(cv "route" "full" '((1.000 25.562) (1.750 25.562)) 0 0 0 nil nil)
schCreateWireLabel(cv nil '(1.250 25.562) "VIOL" "lowerLeft" "R0" "stick" 0.0625 nil)
schCreateWire(cv "route" "full" '((1.000 25.438) (1.750 25.438)) 0 0 0 nil nil)
dbCreateInst(cv noConnMaster "noConn_DCLK_left11_C" '(1.750 25.438) "R90")
schCreateWire(cv "route" "full" '((1.000 25.812) (1.750 25.812)) 0 0 0 nil nil)
schCreateWireLabel(cv nil '(1.250 25.812) "GIOL" "lowerLeft" "R0" "stick" 0.0625 nil)
schCreateWire(cv "route" "full" '((1.000 25.938) (1.750 25.938)) 0 0 0 nil nil)
schCreateWireLabel(cv nil '(1.250 25.938) "DCLK_CORE" "lowerLeft" "R0" "stick" 0.0625 nil)
schCreatePin(cv nil "DCLK_CORE" "inputOutput" nil '(1.750 25.938) "R180")
schCreateWire(cv "route" "full" '((0.000 25.000) (-0.750 25.000)) 0 0 0 nil nil)
schCreateWireLabel(cv nil '(-0.250 25.000) "DCLK" "lowerRight" "R0" "stick" 0.0625 nil)
schCreatePin(cv nil "DCLK" "inputOutput" nil '(-0.750 25.000) "R0")
schCreateWire(cv "route" "full" '((1.000 25.312) (1.750 25.312)) 0 0 0 nil nil)
schCreateWireLabel(cv nil '(1.250 25.312) "POC" "lowerLeft" "R0" "stick" 0.0625 nil)
schCreateWire(cv "route" "full" '((1.000 25.125) (1.750 25.125)) 0 0 0 nil nil)
schCreateWireLabel(cv nil '(1.250 25.125) "VIOL" "lowerLeft" "R0" "stick" 0.0625 nil)
schCreateWire(cv "route" "full" '((1.000 24.938) (1.750 24.938)) 0 0 0 nil nil)
schCreateWireLabel(cv nil '(1.250 24.938) "GIOL" "lowerLeft" "R0" "stick" 0.0625 nil)
schCreateWire(cv "route" "full" '((1.000 24.750) (1.750 24.750)) 0 0 0 nil nil)
schCreateWireLabel(cv nil '(1.250 24.750) "VIOH" "lowerLeft" "R0" "stick" 0.0625 nil)
schCreateWire(cv "route" "full" '((1.000 24.375) (1.750 24.375)) 0 0 0 nil nil)
schCreateWireLabel(cv nil '(1.250 24.375) "GIOH" "lowerLeft" "R0" "stick" 0.0625 nil)
schCheck(cv)
dbSave(cv)
t
