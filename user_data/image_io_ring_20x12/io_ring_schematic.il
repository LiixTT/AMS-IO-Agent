cv = geGetWindowCellView()
pdb3ac_h_gMaster = dbOpenCellView("tphn28hpcpgv18" "PDB3AC_H_G" "symbol")
dbCreateInst(cv pdb3ac_h_gMaster "VREFN_1_left0" '(0 40.8125) "R270")
schCreateWire(cv "route" "full" '((0.000 41.001) (-0.750 41.001)) 0 0 0 nil nil)
schCreateWireLabel(cv nil '(-0.250 41.001) "VREFN<1>" "lowerRight" "R0" "stick" 0.0625 nil)
schCreatePin(cv nil "VREFN<1>" "inputOutput" nil '(-0.750 41.001) "R0")
schCreateWire(cv "route" "full" '((0.875 41.062) (1.625 41.062)) 0 0 0 nil nil)
schCreateWireLabel(cv nil '(1.125 41.062) "GNDCMP" "lowerLeft" "R0" "stick" 0.0625 nil)
schCreateWire(cv "route" "full" '((0.875 40.688) (1.625 40.688)) 0 0 0 nil nil)
schCreateWireLabel(cv nil '(1.125 40.688) "GIOL" "lowerLeft" "R0" "stick" 0.0625 nil)
schCreateWire(cv "route" "full" '((0.875 41.438) (1.625 41.438)) 0 0 0 nil nil)
schCreateWireLabel(cv nil '(1.125 41.438) "VDDCMP" "lowerLeft" "R0" "stick" 0.0625 nil)
dbCreateInst(cv pdb3ac_h_gMaster "VREFN_1_left1" '(0 38.8125) "R270")
schCreateWire(cv "route" "full" '((0.000 39.001) (-0.750 39.001)) 0 0 0 nil nil)
schCreateWireLabel(cv nil '(-0.250 39.001) "VREFN<1>" "lowerRight" "R0" "stick" 0.0625 nil)
schCreatePin(cv nil "VREFN<1>" "inputOutput" nil '(-0.750 39.001) "R0")
schCreateWire(cv "route" "full" '((0.875 39.062) (1.625 39.062)) 0 0 0 nil nil)
schCreateWireLabel(cv nil '(1.125 39.062) "GNDCMP" "lowerLeft" "R0" "stick" 0.0625 nil)
schCreateWire(cv "route" "full" '((0.875 38.688) (1.625 38.688)) 0 0 0 nil nil)
schCreateWireLabel(cv nil '(1.125 38.688) "GIOL" "lowerLeft" "R0" "stick" 0.0625 nil)
schCreateWire(cv "route" "full" '((0.875 39.438) (1.625 39.438)) 0 0 0 nil nil)
schCreateWireLabel(cv nil '(1.125 39.438) "VDDCMP" "lowerLeft" "R0" "stick" 0.0625 nil)
dbCreateInst(cv pdb3ac_h_gMaster "VREFH_1_left2" '(0 36.8125) "R270")
schCreateWire(cv "route" "full" '((0.000 37.001) (-0.750 37.001)) 0 0 0 nil nil)
schCreateWireLabel(cv nil '(-0.250 37.001) "VREFH<1>" "lowerRight" "R0" "stick" 0.0625 nil)
schCreatePin(cv nil "VREFH<1>" "inputOutput" nil '(-0.750 37.001) "R0")
schCreateWire(cv "route" "full" '((0.875 37.062) (1.625 37.062)) 0 0 0 nil nil)
schCreateWireLabel(cv nil '(1.125 37.062) "GNDCMP" "lowerLeft" "R0" "stick" 0.0625 nil)
schCreateWire(cv "route" "full" '((0.875 36.688) (1.625 36.688)) 0 0 0 nil nil)
schCreateWireLabel(cv nil '(1.125 36.688) "GIOL" "lowerLeft" "R0" "stick" 0.0625 nil)
schCreateWire(cv "route" "full" '((0.875 37.438) (1.625 37.438)) 0 0 0 nil nil)
schCreateWireLabel(cv nil '(1.125 37.438) "VDDCMP" "lowerLeft" "R0" "stick" 0.0625 nil)
dbCreateInst(cv pdb3ac_h_gMaster "VREFH_1_left3" '(0 34.8125) "R270")
schCreateWire(cv "route" "full" '((0.000 35.001) (-0.750 35.001)) 0 0 0 nil nil)
schCreateWireLabel(cv nil '(-0.250 35.001) "VREFH<1>" "lowerRight" "R0" "stick" 0.0625 nil)
schCreatePin(cv nil "VREFH<1>" "inputOutput" nil '(-0.750 35.001) "R0")
schCreateWire(cv "route" "full" '((0.875 35.062) (1.625 35.062)) 0 0 0 nil nil)
schCreateWireLabel(cv nil '(1.125 35.062) "GNDCMP" "lowerLeft" "R0" "stick" 0.0625 nil)
schCreateWire(cv "route" "full" '((0.875 34.688) (1.625 34.688)) 0 0 0 nil nil)
schCreateWireLabel(cv nil '(1.125 34.688) "GIOL" "lowerLeft" "R0" "stick" 0.0625 nil)
schCreateWire(cv "route" "full" '((0.875 35.438) (1.625 35.438)) 0 0 0 nil nil)
schCreateWireLabel(cv nil '(1.125 35.438) "VDDCMP" "lowerLeft" "R0" "stick" 0.0625 nil)
dbCreateInst(cv pdb3ac_h_gMaster "VREFH_2_left4" '(0 32.8125) "R270")
schCreateWire(cv "route" "full" '((0.000 33.001) (-0.750 33.001)) 0 0 0 nil nil)
schCreateWireLabel(cv nil '(-0.250 33.001) "VREFH<2>" "lowerRight" "R0" "stick" 0.0625 nil)
schCreatePin(cv nil "VREFH<2>" "inputOutput" nil '(-0.750 33.001) "R0")
schCreateWire(cv "route" "full" '((0.875 33.062) (1.625 33.062)) 0 0 0 nil nil)
schCreateWireLabel(cv nil '(1.125 33.062) "GNDCMP" "lowerLeft" "R0" "stick" 0.0625 nil)
schCreateWire(cv "route" "full" '((0.875 32.688) (1.625 32.688)) 0 0 0 nil nil)
schCreateWireLabel(cv nil '(1.125 32.688) "GIOL" "lowerLeft" "R0" "stick" 0.0625 nil)
schCreateWire(cv "route" "full" '((0.875 33.438) (1.625 33.438)) 0 0 0 nil nil)
schCreateWireLabel(cv nil '(1.125 33.438) "VDDCMP" "lowerLeft" "R0" "stick" 0.0625 nil)
dbCreateInst(cv pdb3ac_h_gMaster "VIN4N_left5" '(0 30.8125) "R270")
schCreateWire(cv "route" "full" '((0.000 31.000) (-0.750 31.000)) 0 0 0 nil nil)
schCreateWireLabel(cv nil '(-0.250 31.000) "VIN4N" "lowerRight" "R0" "stick" 0.0625 nil)
schCreatePin(cv nil "VIN4N" "inputOutput" nil '(-0.750 31.000) "R0")
schCreateWire(cv "route" "full" '((0.875 31.062) (1.625 31.062)) 0 0 0 nil nil)
schCreateWireLabel(cv nil '(1.125 31.062) "GNDCMP" "lowerLeft" "R0" "stick" 0.0625 nil)
schCreateWire(cv "route" "full" '((0.875 30.688) (1.625 30.688)) 0 0 0 nil nil)
schCreateWireLabel(cv nil '(1.125 30.688) "GIOL" "lowerLeft" "R0" "stick" 0.0625 nil)
schCreateWire(cv "route" "full" '((0.875 31.438) (1.625 31.438)) 0 0 0 nil nil)
schCreateWireLabel(cv nil '(1.125 31.438) "VDDCMP" "lowerLeft" "R0" "stick" 0.0625 nil)
dbCreateInst(cv pdb3ac_h_gMaster "VIN4P_left6" '(0 28.8125) "R270")
schCreateWire(cv "route" "full" '((0.000 29.000) (-0.750 29.000)) 0 0 0 nil nil)
schCreateWireLabel(cv nil '(-0.250 29.000) "VIN4P" "lowerRight" "R0" "stick" 0.0625 nil)
schCreatePin(cv nil "VIN4P" "inputOutput" nil '(-0.750 29.000) "R0")
schCreateWire(cv "route" "full" '((0.875 29.062) (1.625 29.062)) 0 0 0 nil nil)
schCreateWireLabel(cv nil '(1.125 29.062) "GNDCMP" "lowerLeft" "R0" "stick" 0.0625 nil)
schCreateWire(cv "route" "full" '((0.875 28.688) (1.625 28.688)) 0 0 0 nil nil)
schCreateWireLabel(cv nil '(1.125 28.688) "GIOL" "lowerLeft" "R0" "stick" 0.0625 nil)
schCreateWire(cv "route" "full" '((0.875 29.438) (1.625 29.438)) 0 0 0 nil nil)
schCreateWireLabel(cv nil '(1.125 29.438) "VDDCMP" "lowerLeft" "R0" "stick" 0.0625 nil)
dbCreateInst(cv pdb3ac_h_gMaster "VREFH_2_left7" '(0 26.8125) "R270")
schCreateWire(cv "route" "full" '((0.000 27.000) (-0.750 27.000)) 0 0 0 nil nil)
schCreateWireLabel(cv nil '(-0.250 27.000) "VREFH<2>" "lowerRight" "R0" "stick" 0.0625 nil)
schCreatePin(cv nil "VREFH<2>" "inputOutput" nil '(-0.750 27.000) "R0")
schCreateWire(cv "route" "full" '((0.875 27.062) (1.625 27.062)) 0 0 0 nil nil)
schCreateWireLabel(cv nil '(1.125 27.062) "GNDCMP" "lowerLeft" "R0" "stick" 0.0625 nil)
schCreateWire(cv "route" "full" '((0.875 26.688) (1.625 26.688)) 0 0 0 nil nil)
schCreateWireLabel(cv nil '(1.125 26.688) "GIOL" "lowerLeft" "R0" "stick" 0.0625 nil)
schCreateWire(cv "route" "full" '((0.875 27.438) (1.625 27.438)) 0 0 0 nil nil)
schCreateWireLabel(cv nil '(1.125 27.438) "VDDCMP" "lowerLeft" "R0" "stick" 0.0625 nil)
dbCreateInst(cv pdb3ac_h_gMaster "VIN3N_left8" '(0 24.8125) "R270")
schCreateWire(cv "route" "full" '((0.000 25.000) (-0.750 25.000)) 0 0 0 nil nil)
schCreateWireLabel(cv nil '(-0.250 25.000) "VIN3N" "lowerRight" "R0" "stick" 0.0625 nil)
schCreatePin(cv nil "VIN3N" "inputOutput" nil '(-0.750 25.000) "R0")
schCreateWire(cv "route" "full" '((0.875 25.062) (1.625 25.062)) 0 0 0 nil nil)
schCreateWireLabel(cv nil '(1.125 25.062) "GNDCMP" "lowerLeft" "R0" "stick" 0.0625 nil)
schCreateWire(cv "route" "full" '((0.875 24.688) (1.625 24.688)) 0 0 0 nil nil)
schCreateWireLabel(cv nil '(1.125 24.688) "GIOL" "lowerLeft" "R0" "stick" 0.0625 nil)
schCreateWire(cv "route" "full" '((0.875 25.438) (1.625 25.438)) 0 0 0 nil nil)
schCreateWireLabel(cv nil '(1.125 25.438) "VDDCMP" "lowerLeft" "R0" "stick" 0.0625 nil)
dbCreateInst(cv pdb3ac_h_gMaster "VIN3P_left9" '(0 22.8125) "R270")
schCreateWire(cv "route" "full" '((0.000 23.000) (-0.750 23.000)) 0 0 0 nil nil)
schCreateWireLabel(cv nil '(-0.250 23.000) "VIN3P" "lowerRight" "R0" "stick" 0.0625 nil)
schCreatePin(cv nil "VIN3P" "inputOutput" nil '(-0.750 23.000) "R0")
schCreateWire(cv "route" "full" '((0.875 23.062) (1.625 23.062)) 0 0 0 nil nil)
schCreateWireLabel(cv nil '(1.125 23.062) "GNDCMP" "lowerLeft" "R0" "stick" 0.0625 nil)
schCreateWire(cv "route" "full" '((0.875 22.688) (1.625 22.688)) 0 0 0 nil nil)
schCreateWireLabel(cv nil '(1.125 22.688) "GIOL" "lowerLeft" "R0" "stick" 0.0625 nil)
schCreateWire(cv "route" "full" '((0.875 23.438) (1.625 23.438)) 0 0 0 nil nil)
schCreateWireLabel(cv nil '(1.125 23.438) "VDDCMP" "lowerLeft" "R0" "stick" 0.0625 nil)
dbCreateInst(cv pdb3ac_h_gMaster "VREFH_2_left10" '(0 20.8125) "R270")
schCreateWire(cv "route" "full" '((0.000 21.000) (-0.750 21.000)) 0 0 0 nil nil)
schCreateWireLabel(cv nil '(-0.250 21.000) "VREFH<2>" "lowerRight" "R0" "stick" 0.0625 nil)
schCreatePin(cv nil "VREFH<2>" "inputOutput" nil '(-0.750 21.000) "R0")
schCreateWire(cv "route" "full" '((0.875 21.062) (1.625 21.062)) 0 0 0 nil nil)
schCreateWireLabel(cv nil '(1.125 21.062) "GNDCMP" "lowerLeft" "R0" "stick" 0.0625 nil)
schCreateWire(cv "route" "full" '((0.875 20.688) (1.625 20.688)) 0 0 0 nil nil)
schCreateWireLabel(cv nil '(1.125 20.688) "GIOL" "lowerLeft" "R0" "stick" 0.0625 nil)
schCreateWire(cv "route" "full" '((0.875 21.438) (1.625 21.438)) 0 0 0 nil nil)
schCreateWireLabel(cv nil '(1.125 21.438) "VDDCMP" "lowerLeft" "R0" "stick" 0.0625 nil)
dbCreateInst(cv pdb3ac_h_gMaster "VREFH_2_left11" '(0 18.8125) "R270")
schCreateWire(cv "route" "full" '((0.000 19.000) (-0.750 19.000)) 0 0 0 nil nil)
schCreateWireLabel(cv nil '(-0.250 19.000) "VREFH<2>" "lowerRight" "R0" "stick" 0.0625 nil)
schCreatePin(cv nil "VREFH<2>" "inputOutput" nil '(-0.750 19.000) "R0")
schCreateWire(cv "route" "full" '((0.875 19.062) (1.625 19.062)) 0 0 0 nil nil)
schCreateWireLabel(cv nil '(1.125 19.062) "GNDCMP" "lowerLeft" "R0" "stick" 0.0625 nil)
schCreateWire(cv "route" "full" '((0.875 18.688) (1.625 18.688)) 0 0 0 nil nil)
schCreateWireLabel(cv nil '(1.125 18.688) "GIOL" "lowerLeft" "R0" "stick" 0.0625 nil)
schCreateWire(cv "route" "full" '((0.875 19.438) (1.625 19.438)) 0 0 0 nil nil)
schCreateWireLabel(cv nil '(1.125 19.438) "VDDCMP" "lowerLeft" "R0" "stick" 0.0625 nil)
dbCreateInst(cv pdb3ac_h_gMaster "VREFN_2_left12" '(0 16.8125) "R270")
schCreateWire(cv "route" "full" '((0.000 17.000) (-0.750 17.000)) 0 0 0 nil nil)
schCreateWireLabel(cv nil '(-0.250 17.000) "VREFN<2>" "lowerRight" "R0" "stick" 0.0625 nil)
schCreatePin(cv nil "VREFN<2>" "inputOutput" nil '(-0.750 17.000) "R0")
schCreateWire(cv "route" "full" '((0.875 17.062) (1.625 17.062)) 0 0 0 nil nil)
schCreateWireLabel(cv nil '(1.125 17.062) "GNDCMP" "lowerLeft" "R0" "stick" 0.0625 nil)
schCreateWire(cv "route" "full" '((0.875 16.688) (1.625 16.688)) 0 0 0 nil nil)
schCreateWireLabel(cv nil '(1.125 16.688) "GIOL" "lowerLeft" "R0" "stick" 0.0625 nil)
schCreateWire(cv "route" "full" '((0.875 17.438) (1.625 17.438)) 0 0 0 nil nil)
schCreateWireLabel(cv nil '(1.125 17.438) "VDDCMP" "lowerLeft" "R0" "stick" 0.0625 nil)
dbCreateInst(cv pdb3ac_h_gMaster "VREFN_2_left13" '(0 14.8125) "R270")
schCreateWire(cv "route" "full" '((0.000 15.001) (-0.750 15.001)) 0 0 0 nil nil)
schCreateWireLabel(cv nil '(-0.250 15.001) "VREFN<2>" "lowerRight" "R0" "stick" 0.0625 nil)
schCreatePin(cv nil "VREFN<2>" "inputOutput" nil '(-0.750 15.001) "R0")
schCreateWire(cv "route" "full" '((0.875 15.062) (1.625 15.062)) 0 0 0 nil nil)
schCreateWireLabel(cv nil '(1.125 15.062) "GNDCMP" "lowerLeft" "R0" "stick" 0.0625 nil)
schCreateWire(cv "route" "full" '((0.875 14.688) (1.625 14.688)) 0 0 0 nil nil)
schCreateWireLabel(cv nil '(1.125 14.688) "GIOL" "lowerLeft" "R0" "stick" 0.0625 nil)
schCreateWire(cv "route" "full" '((0.875 15.438) (1.625 15.438)) 0 0 0 nil nil)
schCreateWireLabel(cv nil '(1.125 15.438) "VDDCMP" "lowerLeft" "R0" "stick" 0.0625 nil)
dbCreateInst(cv pdb3ac_h_gMaster "VIN2N_left14" '(0 12.8125) "R270")
schCreateWire(cv "route" "full" '((0.000 13.001) (-0.750 13.001)) 0 0 0 nil nil)
schCreateWireLabel(cv nil '(-0.250 13.001) "VIN2N" "lowerRight" "R0" "stick" 0.0625 nil)
schCreatePin(cv nil "VIN2N" "inputOutput" nil '(-0.750 13.001) "R0")
schCreateWire(cv "route" "full" '((0.875 13.062) (1.625 13.062)) 0 0 0 nil nil)
schCreateWireLabel(cv nil '(1.125 13.062) "GNDCMP" "lowerLeft" "R0" "stick" 0.0625 nil)
schCreateWire(cv "route" "full" '((0.875 12.688) (1.625 12.688)) 0 0 0 nil nil)
schCreateWireLabel(cv nil '(1.125 12.688) "GIOL" "lowerLeft" "R0" "stick" 0.0625 nil)
schCreateWire(cv "route" "full" '((0.875 13.438) (1.625 13.438)) 0 0 0 nil nil)
schCreateWireLabel(cv nil '(1.125 13.438) "VDDCMP" "lowerLeft" "R0" "stick" 0.0625 nil)
dbCreateInst(cv pdb3ac_h_gMaster "VIN2P_left15" '(0 10.8125) "R270")
schCreateWire(cv "route" "full" '((0.000 11.001) (-0.750 11.001)) 0 0 0 nil nil)
schCreateWireLabel(cv nil '(-0.250 11.001) "VIN2P" "lowerRight" "R0" "stick" 0.0625 nil)
schCreatePin(cv nil "VIN2P" "inputOutput" nil '(-0.750 11.001) "R0")
schCreateWire(cv "route" "full" '((0.875 11.062) (1.625 11.062)) 0 0 0 nil nil)
schCreateWireLabel(cv nil '(1.125 11.062) "GNDCMP" "lowerLeft" "R0" "stick" 0.0625 nil)
schCreateWire(cv "route" "full" '((0.875 10.688) (1.625 10.688)) 0 0 0 nil nil)
schCreateWireLabel(cv nil '(1.125 10.688) "GIOL" "lowerLeft" "R0" "stick" 0.0625 nil)
schCreateWire(cv "route" "full" '((0.875 11.438) (1.625 11.438)) 0 0 0 nil nil)
schCreateWireLabel(cv nil '(1.125 11.438) "VDDCMP" "lowerLeft" "R0" "stick" 0.0625 nil)
dbCreateInst(cv pdb3ac_h_gMaster "VREFN_2_left16" '(0 8.8125) "R270")
schCreateWire(cv "route" "full" '((0.000 9.001) (-0.750 9.001)) 0 0 0 nil nil)
schCreateWireLabel(cv nil '(-0.250 9.001) "VREFN<2>" "lowerRight" "R0" "stick" 0.0625 nil)
schCreatePin(cv nil "VREFN<2>" "inputOutput" nil '(-0.750 9.001) "R0")
schCreateWire(cv "route" "full" '((0.875 9.062) (1.625 9.062)) 0 0 0 nil nil)
schCreateWireLabel(cv nil '(1.125 9.062) "GNDCMP" "lowerLeft" "R0" "stick" 0.0625 nil)
schCreateWire(cv "route" "full" '((0.875 8.688) (1.625 8.688)) 0 0 0 nil nil)
schCreateWireLabel(cv nil '(1.125 8.688) "GIOL" "lowerLeft" "R0" "stick" 0.0625 nil)
schCreateWire(cv "route" "full" '((0.875 9.438) (1.625 9.438)) 0 0 0 nil nil)
schCreateWireLabel(cv nil '(1.125 9.438) "VDDCMP" "lowerLeft" "R0" "stick" 0.0625 nil)
dbCreateInst(cv pdb3ac_h_gMaster "VIN1N_left17" '(0 6.8125) "R270")
schCreateWire(cv "route" "full" '((0.000 7.000) (-0.750 7.000)) 0 0 0 nil nil)
schCreateWireLabel(cv nil '(-0.250 7.000) "VIN1N" "lowerRight" "R0" "stick" 0.0625 nil)
schCreatePin(cv nil "VIN1N" "inputOutput" nil '(-0.750 7.000) "R0")
schCreateWire(cv "route" "full" '((0.875 7.062) (1.625 7.062)) 0 0 0 nil nil)
schCreateWireLabel(cv nil '(1.125 7.062) "GNDCMP" "lowerLeft" "R0" "stick" 0.0625 nil)
schCreateWire(cv "route" "full" '((0.875 6.688) (1.625 6.688)) 0 0 0 nil nil)
schCreateWireLabel(cv nil '(1.125 6.688) "GIOL" "lowerLeft" "R0" "stick" 0.0625 nil)
schCreateWire(cv "route" "full" '((0.875 7.438) (1.625 7.438)) 0 0 0 nil nil)
schCreateWireLabel(cv nil '(1.125 7.438) "VDDCMP" "lowerLeft" "R0" "stick" 0.0625 nil)
dbCreateInst(cv pdb3ac_h_gMaster "VIN1P_left18" '(0 4.8125) "R270")
schCreateWire(cv "route" "full" '((0.000 5.000) (-0.750 5.000)) 0 0 0 nil nil)
schCreateWireLabel(cv nil '(-0.250 5.000) "VIN1P" "lowerRight" "R0" "stick" 0.0625 nil)
schCreatePin(cv nil "VIN1P" "inputOutput" nil '(-0.750 5.000) "R0")
schCreateWire(cv "route" "full" '((0.875 5.062) (1.625 5.062)) 0 0 0 nil nil)
schCreateWireLabel(cv nil '(1.125 5.062) "GNDCMP" "lowerLeft" "R0" "stick" 0.0625 nil)
schCreateWire(cv "route" "full" '((0.875 4.688) (1.625 4.688)) 0 0 0 nil nil)
schCreateWireLabel(cv nil '(1.125 4.688) "GIOL" "lowerLeft" "R0" "stick" 0.0625 nil)
schCreateWire(cv "route" "full" '((0.875 5.438) (1.625 5.438)) 0 0 0 nil nil)
schCreateWireLabel(cv nil '(1.125 5.438) "VDDCMP" "lowerLeft" "R0" "stick" 0.0625 nil)
dbCreateInst(cv pdb3ac_h_gMaster "VREFN_2_left19" '(0 2.8125) "R270")
schCreateWire(cv "route" "full" '((0.000 3.001) (-0.750 3.001)) 0 0 0 nil nil)
schCreateWireLabel(cv nil '(-0.250 3.001) "VREFN<2>" "lowerRight" "R0" "stick" 0.0625 nil)
schCreatePin(cv nil "VREFN<2>" "inputOutput" nil '(-0.750 3.001) "R0")
schCreateWire(cv "route" "full" '((0.875 3.062) (1.625 3.062)) 0 0 0 nil nil)
schCreateWireLabel(cv nil '(1.125 3.062) "GNDCMP" "lowerLeft" "R0" "stick" 0.0625 nil)
schCreateWire(cv "route" "full" '((0.875 2.688) (1.625 2.688)) 0 0 0 nil nil)
schCreateWireLabel(cv nil '(1.125 2.688) "GIOL" "lowerLeft" "R0" "stick" 0.0625 nil)
schCreateWire(cv "route" "full" '((0.875 3.438) (1.625 3.438)) 0 0 0 nil nil)
schCreateWireLabel(cv nil '(1.125 3.438) "VDDCMP" "lowerLeft" "R0" "stick" 0.0625 nil)
pdb3ac_v_gMaster = dbOpenCellView("tphn28hpcpgv18" "PDB3AC_V_G" "symbol")
dbCreateInst(cv pdb3ac_v_gMaster "VINCM_bottom0" '(3.1875 0) "R0")
schCreateWire(cv "route" "full" '((2.999 0.000) (2.999 -0.750)) 0 0 0 nil nil)
schCreateWireLabel(cv nil '(2.999 -0.250) "VINCM" "lowerRight" "R90" "stick" 0.0625 nil)
schCreatePin(cv nil "VINCM" "inputOutput" nil '(2.999 -0.750) "R90")
schCreateWire(cv "route" "full" '((2.938 0.875) (2.938 1.625)) 0 0 0 nil nil)
schCreateWireLabel(cv nil '(2.938 1.125) "GNDCMP" "lowerLeft" "R90" "stick" 0.0625 nil)
schCreateWire(cv "route" "full" '((3.312 0.875) (3.312 1.625)) 0 0 0 nil nil)
schCreateWireLabel(cv nil '(3.312 1.125) "GIOL" "lowerLeft" "R90" "stick" 0.0625 nil)
schCreateWire(cv "route" "full" '((2.562 0.875) (2.562 1.625)) 0 0 0 nil nil)
schCreateWireLabel(cv nil '(2.562 1.125) "VDDCMP" "lowerLeft" "R90" "stick" 0.0625 nil)
pvss3ac_v_gMaster = dbOpenCellView("tphn28hpcpgv18" "PVSS3AC_V_G" "symbol")
dbCreateInst(cv pvss3ac_v_gMaster "GNDCMP_bottom1" '(5.1875 0) "R0")
schCreateWire(cv "route" "full" '((5.000 0.000) (5.000 -0.750)) 0 0 0 nil nil)
schCreateWireLabel(cv nil '(5.000 -0.250) "GNDCMP" "lowerRight" "R90" "stick" 0.0625 nil)
schCreatePin(cv nil "GNDCMP" "inputOutput" nil '(5.000 -0.750) "R90")
schCreateWire(cv "route" "full" '((5.312 0.875) (5.312 1.625)) 0 0 0 nil nil)
schCreateWireLabel(cv nil '(5.312 1.125) "GIOL" "lowerLeft" "R90" "stick" 0.0625 nil)
schCreateWire(cv "route" "full" '((4.562 0.875) (4.562 1.625)) 0 0 0 nil nil)
schCreateWireLabel(cv nil '(4.562 1.125) "GNDCMP_CORE" "lowerLeft" "R90" "stick" 0.0625 nil)
schCreatePin(cv nil "GNDCMP_CORE" "inputOutput" nil '(4.562 1.625) "R270")
schCreateWire(cv "route" "full" '((4.938 0.875) (4.938 1.625)) 0 0 0 nil nil)
schCreateWireLabel(cv nil '(4.938 1.125) "VDDCMP" "lowerLeft" "R90" "stick" 0.0625 nil)
pvdd3ac_v_gMaster = dbOpenCellView("tphn28hpcpgv18" "PVDD3AC_V_G" "symbol")
dbCreateInst(cv pvdd3ac_v_gMaster "VDDCMP_bottom2" '(7.1875 0) "R0")
schCreateWire(cv "route" "full" '((6.562 0.875) (6.562 1.625)) 0 0 0 nil nil)
schCreateWireLabel(cv nil '(6.562 1.125) "VDDCMP_CORE" "lowerLeft" "R90" "stick" 0.0625 nil)
schCreatePin(cv nil "VDDCMP_CORE" "inputOutput" nil '(6.562 1.625) "R270")
schCreateWire(cv "route" "full" '((6.938 0.875) (6.938 1.625)) 0 0 0 nil nil)
schCreateWireLabel(cv nil '(6.938 1.125) "GNDCMP" "lowerLeft" "R90" "stick" 0.0625 nil)
schCreateWire(cv "route" "full" '((7.312 0.875) (7.312 1.625)) 0 0 0 nil nil)
schCreateWireLabel(cv nil '(7.312 1.125) "GIOL" "lowerLeft" "R90" "stick" 0.0625 nil)
schCreateWire(cv "route" "full" '((7.000 0.000) (7.000 -0.750)) 0 0 0 nil nil)
schCreateWireLabel(cv nil '(7.000 -0.250) "VDDCMP" "lowerRight" "R90" "stick" 0.0625 nil)
schCreatePin(cv nil "VDDCMP" "inputOutput" nil '(7.000 -0.750) "R90")
pvss1ac_v_gMaster = dbOpenCellView("tphn28hpcpgv18" "PVSS1AC_V_G" "symbol")
dbCreateInst(cv pvss1ac_v_gMaster "GNDANA_bottom3" '(9.1875 0) "R0")
schCreateWire(cv "route" "full" '((8.999 0.000) (8.999 -0.750)) 0 0 0 nil nil)
schCreateWireLabel(cv nil '(8.999 -0.250) "GNDANA" "lowerRight" "R90" "stick" 0.0625 nil)
schCreatePin(cv nil "GNDANA" "inputOutput" nil '(8.999 -0.750) "R90")
schCreateWire(cv "route" "full" '((8.938 0.875) (8.938 1.625)) 0 0 0 nil nil)
schCreateWireLabel(cv nil '(8.938 1.125) "GNDCMP" "lowerLeft" "R90" "stick" 0.0625 nil)
schCreateWire(cv "route" "full" '((9.312 0.875) (9.312 1.625)) 0 0 0 nil nil)
schCreateWireLabel(cv nil '(9.312 1.125) "GIOL" "lowerLeft" "R90" "stick" 0.0625 nil)
schCreateWire(cv "route" "full" '((8.562 0.875) (8.562 1.625)) 0 0 0 nil nil)
schCreateWireLabel(cv nil '(8.562 1.125) "VDDCMP" "lowerLeft" "R90" "stick" 0.0625 nil)
pvdd1ac_v_gMaster = dbOpenCellView("tphn28hpcpgv18" "PVDD1AC_V_G" "symbol")
dbCreateInst(cv pvdd1ac_v_gMaster "VDDANA_bottom4" '(11.1875 0) "R0")
schCreateWire(cv "route" "full" '((10.938 0.875) (10.938 1.625)) 0 0 0 nil nil)
schCreateWireLabel(cv nil '(10.938 1.125) "GNDCMP" "lowerLeft" "R90" "stick" 0.0625 nil)
schCreateWire(cv "route" "full" '((11.312 0.875) (11.312 1.625)) 0 0 0 nil nil)
schCreateWireLabel(cv nil '(11.312 1.125) "GIOL" "lowerLeft" "R90" "stick" 0.0625 nil)
schCreateWire(cv "route" "full" '((10.999 0.000) (10.999 -0.750)) 0 0 0 nil nil)
schCreateWireLabel(cv nil '(10.999 -0.250) "VDDANA" "lowerRight" "R90" "stick" 0.0625 nil)
schCreatePin(cv nil "VDDANA" "inputOutput" nil '(10.999 -0.750) "R90")
schCreateWire(cv "route" "full" '((10.562 0.875) (10.562 1.625)) 0 0 0 nil nil)
schCreateWireLabel(cv nil '(10.562 1.125) "VDDCMP" "lowerLeft" "R90" "stick" 0.0625 nil)
dbCreateInst(cv pvss1ac_v_gMaster "GNDGM_bottom5" '(13.1875 0) "R0")
schCreateWire(cv "route" "full" '((12.999 0.000) (12.999 -0.750)) 0 0 0 nil nil)
schCreateWireLabel(cv nil '(12.999 -0.250) "GNDGM" "lowerRight" "R90" "stick" 0.0625 nil)
schCreatePin(cv nil "GNDGM" "inputOutput" nil '(12.999 -0.750) "R90")
schCreateWire(cv "route" "full" '((12.938 0.875) (12.938 1.625)) 0 0 0 nil nil)
schCreateWireLabel(cv nil '(12.938 1.125) "GNDCMP" "lowerLeft" "R90" "stick" 0.0625 nil)
schCreateWire(cv "route" "full" '((13.312 0.875) (13.312 1.625)) 0 0 0 nil nil)
schCreateWireLabel(cv nil '(13.312 1.125) "GIOL" "lowerLeft" "R90" "stick" 0.0625 nil)
schCreateWire(cv "route" "full" '((12.562 0.875) (12.562 1.625)) 0 0 0 nil nil)
schCreateWireLabel(cv nil '(12.562 1.125) "VDDCMP" "lowerLeft" "R90" "stick" 0.0625 nil)
dbCreateInst(cv pvdd1ac_v_gMaster "VDDGM_bottom6" '(15.1875 0) "R0")
schCreateWire(cv "route" "full" '((14.938 0.875) (14.938 1.625)) 0 0 0 nil nil)
schCreateWireLabel(cv nil '(14.938 1.125) "GNDCMP" "lowerLeft" "R90" "stick" 0.0625 nil)
schCreateWire(cv "route" "full" '((15.312 0.875) (15.312 1.625)) 0 0 0 nil nil)
schCreateWireLabel(cv nil '(15.312 1.125) "GIOL" "lowerLeft" "R90" "stick" 0.0625 nil)
schCreateWire(cv "route" "full" '((14.999 0.000) (14.999 -0.750)) 0 0 0 nil nil)
schCreateWireLabel(cv nil '(14.999 -0.250) "VDDGM" "lowerRight" "R90" "stick" 0.0625 nil)
schCreatePin(cv nil "VDDGM" "inputOutput" nil '(14.999 -0.750) "R90")
schCreateWire(cv "route" "full" '((14.562 0.875) (14.562 1.625)) 0 0 0 nil nil)
schCreateWireLabel(cv nil '(14.562 1.125) "VDDCMP" "lowerLeft" "R90" "stick" 0.0625 nil)
dbCreateInst(cv pvss1ac_v_gMaster "GNDTIA_bottom7" '(17.1875 0) "R0")
schCreateWire(cv "route" "full" '((17.000 0.000) (17.000 -0.750)) 0 0 0 nil nil)
schCreateWireLabel(cv nil '(17.000 -0.250) "GNDTIA" "lowerRight" "R90" "stick" 0.0625 nil)
schCreatePin(cv nil "GNDTIA" "inputOutput" nil '(17.000 -0.750) "R90")
schCreateWire(cv "route" "full" '((16.938 0.875) (16.938 1.625)) 0 0 0 nil nil)
schCreateWireLabel(cv nil '(16.938 1.125) "GNDCMP" "lowerLeft" "R90" "stick" 0.0625 nil)
schCreateWire(cv "route" "full" '((17.312 0.875) (17.312 1.625)) 0 0 0 nil nil)
schCreateWireLabel(cv nil '(17.312 1.125) "GIOL" "lowerLeft" "R90" "stick" 0.0625 nil)
schCreateWire(cv "route" "full" '((16.562 0.875) (16.562 1.625)) 0 0 0 nil nil)
schCreateWireLabel(cv nil '(16.562 1.125) "VDDCMP" "lowerLeft" "R90" "stick" 0.0625 nil)
dbCreateInst(cv pvdd1ac_v_gMaster "VDDTIA_bottom8" '(19.1875 0) "R0")
schCreateWire(cv "route" "full" '((18.938 0.875) (18.938 1.625)) 0 0 0 nil nil)
schCreateWireLabel(cv nil '(18.938 1.125) "GNDCMP" "lowerLeft" "R90" "stick" 0.0625 nil)
schCreateWire(cv "route" "full" '((19.312 0.875) (19.312 1.625)) 0 0 0 nil nil)
schCreateWireLabel(cv nil '(19.312 1.125) "GIOL" "lowerLeft" "R90" "stick" 0.0625 nil)
schCreateWire(cv "route" "full" '((19.000 0.000) (19.000 -0.750)) 0 0 0 nil nil)
schCreateWireLabel(cv nil '(19.000 -0.250) "VDDTIA" "lowerRight" "R90" "stick" 0.0625 nil)
schCreatePin(cv nil "VDDTIA" "inputOutput" nil '(19.000 -0.750) "R90")
schCreateWire(cv "route" "full" '((18.562 0.875) (18.562 1.625)) 0 0 0 nil nil)
schCreateWireLabel(cv nil '(18.562 1.125) "VDDCMP" "lowerLeft" "R90" "stick" 0.0625 nil)
dbCreateInst(cv pdb3ac_v_gMaster "VCM_bottom9" '(21.1875 0) "R0")
schCreateWire(cv "route" "full" '((21.000 0.000) (21.000 -0.750)) 0 0 0 nil nil)
schCreateWireLabel(cv nil '(21.000 -0.250) "VCM" "lowerRight" "R90" "stick" 0.0625 nil)
schCreatePin(cv nil "VCM" "inputOutput" nil '(21.000 -0.750) "R90")
schCreateWire(cv "route" "full" '((20.938 0.875) (20.938 1.625)) 0 0 0 nil nil)
schCreateWireLabel(cv nil '(20.938 1.125) "GNDCMP" "lowerLeft" "R90" "stick" 0.0625 nil)
schCreateWire(cv "route" "full" '((21.312 0.875) (21.312 1.625)) 0 0 0 nil nil)
schCreateWireLabel(cv nil '(21.312 1.125) "GIOL" "lowerLeft" "R90" "stick" 0.0625 nil)
schCreateWire(cv "route" "full" '((20.562 0.875) (20.562 1.625)) 0 0 0 nil nil)
schCreateWireLabel(cv nil '(20.562 1.125) "VDDCMP" "lowerLeft" "R90" "stick" 0.0625 nil)
dbCreateInst(cv pdb3ac_v_gMaster "CLKP_bottom10" '(23.1875 0) "R0")
schCreateWire(cv "route" "full" '((23.000 0.000) (23.000 -0.750)) 0 0 0 nil nil)
schCreateWireLabel(cv nil '(23.000 -0.250) "CLKP" "lowerRight" "R90" "stick" 0.0625 nil)
schCreatePin(cv nil "CLKP" "inputOutput" nil '(23.000 -0.750) "R90")
schCreateWire(cv "route" "full" '((22.938 0.875) (22.938 1.625)) 0 0 0 nil nil)
schCreateWireLabel(cv nil '(22.938 1.125) "GNDCMP" "lowerLeft" "R90" "stick" 0.0625 nil)
schCreateWire(cv "route" "full" '((23.312 0.875) (23.312 1.625)) 0 0 0 nil nil)
schCreateWireLabel(cv nil '(23.312 1.125) "GIOL" "lowerLeft" "R90" "stick" 0.0625 nil)
schCreateWire(cv "route" "full" '((22.562 0.875) (22.562 1.625)) 0 0 0 nil nil)
schCreateWireLabel(cv nil '(22.562 1.125) "VDDCMP" "lowerLeft" "R90" "stick" 0.0625 nil)
dbCreateInst(cv pdb3ac_v_gMaster "CLKN_bottom11" '(25.1875 0) "R0")
schCreateWire(cv "route" "full" '((25.000 0.000) (25.000 -0.750)) 0 0 0 nil nil)
schCreateWireLabel(cv nil '(25.000 -0.250) "CLKN" "lowerRight" "R90" "stick" 0.0625 nil)
schCreatePin(cv nil "CLKN" "inputOutput" nil '(25.000 -0.750) "R90")
schCreateWire(cv "route" "full" '((24.938 0.875) (24.938 1.625)) 0 0 0 nil nil)
schCreateWireLabel(cv nil '(24.938 1.125) "GNDCMP" "lowerLeft" "R90" "stick" 0.0625 nil)
schCreateWire(cv "route" "full" '((25.312 0.875) (25.312 1.625)) 0 0 0 nil nil)
schCreateWireLabel(cv nil '(25.312 1.125) "GIOL" "lowerLeft" "R90" "stick" 0.0625 nil)
schCreateWire(cv "route" "full" '((24.562 0.875) (24.562 1.625)) 0 0 0 nil nil)
schCreateWireLabel(cv nil '(24.562 1.125) "VDDCMP" "lowerLeft" "R90" "stick" 0.0625 nil)
pvss1ac_h_gMaster = dbOpenCellView("tphn28hpcpgv18" "PVSS1AC_H_G" "symbol")
dbCreateInst(cv pvss1ac_h_gMaster "GNDCKB_right0" '(28.0 3.1875) "R90")
schCreateWire(cv "route" "full" '((28.000 2.999) (28.750 2.999)) 0 0 0 nil nil)
schCreateWireLabel(cv nil '(28.250 2.999) "GNDCKB" "lowerLeft" "R0" "stick" 0.0625 nil)
schCreatePin(cv nil "GNDCKB" "inputOutput" nil '(28.750 2.999) "R180")
schCreateWire(cv "route" "full" '((27.125 2.938) (26.375 2.938)) 0 0 0 nil nil)
schCreateWireLabel(cv nil '(26.875 2.938) "GNDCMP" "lowerRight" "R0" "stick" 0.0625 nil)
schCreateWire(cv "route" "full" '((27.125 3.312) (26.375 3.312)) 0 0 0 nil nil)
schCreateWireLabel(cv nil '(26.875 3.312) "GIOL" "lowerRight" "R0" "stick" 0.0625 nil)
schCreateWire(cv "route" "full" '((27.125 2.562) (26.375 2.562)) 0 0 0 nil nil)
schCreateWireLabel(cv nil '(26.875 2.562) "VDDCMP" "lowerRight" "R0" "stick" 0.0625 nil)
pvdd1ac_h_gMaster = dbOpenCellView("tphn28hpcpgv18" "PVDD1AC_H_G" "symbol")
dbCreateInst(cv pvdd1ac_h_gMaster "VDDCKB_right1" '(28.0 5.1875) "R90")
schCreateWire(cv "route" "full" '((27.125 4.938) (26.375 4.938)) 0 0 0 nil nil)
schCreateWireLabel(cv nil '(26.875 4.938) "GNDCMP" "lowerRight" "R0" "stick" 0.0625 nil)
schCreateWire(cv "route" "full" '((27.125 5.312) (26.375 5.312)) 0 0 0 nil nil)
schCreateWireLabel(cv nil '(26.875 5.312) "GIOL" "lowerRight" "R0" "stick" 0.0625 nil)
schCreateWire(cv "route" "full" '((28.000 5.000) (28.750 5.000)) 0 0 0 nil nil)
schCreateWireLabel(cv nil '(28.250 5.000) "VDDCKB" "lowerLeft" "R0" "stick" 0.0625 nil)
schCreatePin(cv nil "VDDCKB" "inputOutput" nil '(28.750 5.000) "R180")
schCreateWire(cv "route" "full" '((27.125 4.562) (26.375 4.562)) 0 0 0 nil nil)
schCreateWireLabel(cv nil '(26.875 4.562) "VDDCMP" "lowerRight" "R0" "stick" 0.0625 nil)
dbCreateInst(cv pvss1ac_h_gMaster "GNDCLK_right2" '(28.0 7.1875) "R90")
schCreateWire(cv "route" "full" '((28.000 7.000) (28.750 7.000)) 0 0 0 nil nil)
schCreateWireLabel(cv nil '(28.250 7.000) "GNDCLK" "lowerLeft" "R0" "stick" 0.0625 nil)
schCreatePin(cv nil "GNDCLK" "inputOutput" nil '(28.750 7.000) "R180")
schCreateWire(cv "route" "full" '((27.125 6.938) (26.375 6.938)) 0 0 0 nil nil)
schCreateWireLabel(cv nil '(26.875 6.938) "GNDCMP" "lowerRight" "R0" "stick" 0.0625 nil)
schCreateWire(cv "route" "full" '((27.125 7.312) (26.375 7.312)) 0 0 0 nil nil)
schCreateWireLabel(cv nil '(26.875 7.312) "GIOL" "lowerRight" "R0" "stick" 0.0625 nil)
schCreateWire(cv "route" "full" '((27.125 6.562) (26.375 6.562)) 0 0 0 nil nil)
schCreateWireLabel(cv nil '(26.875 6.562) "VDDCMP" "lowerRight" "R0" "stick" 0.0625 nil)
dbCreateInst(cv pvdd1ac_h_gMaster "VDDCLK_right3" '(28.0 9.1875) "R90")
schCreateWire(cv "route" "full" '((27.125 8.938) (26.375 8.938)) 0 0 0 nil nil)
schCreateWireLabel(cv nil '(26.875 8.938) "GNDCMP" "lowerRight" "R0" "stick" 0.0625 nil)
schCreateWire(cv "route" "full" '((27.125 9.312) (26.375 9.312)) 0 0 0 nil nil)
schCreateWireLabel(cv nil '(26.875 9.312) "GIOL" "lowerRight" "R0" "stick" 0.0625 nil)
schCreateWire(cv "route" "full" '((28.000 8.999) (28.750 8.999)) 0 0 0 nil nil)
schCreateWireLabel(cv nil '(28.250 8.999) "VDDCLK" "lowerLeft" "R0" "stick" 0.0625 nil)
schCreatePin(cv nil "VDDCLK" "inputOutput" nil '(28.750 8.999) "R180")
schCreateWire(cv "route" "full" '((27.125 8.562) (26.375 8.562)) 0 0 0 nil nil)
schCreateWireLabel(cv nil '(26.875 8.562) "VDDCMP" "lowerRight" "R0" "stick" 0.0625 nil)
dbCreateInst(cv pdb3ac_h_gMaster "IB_right4" '(28.0 11.1875) "R90")
schCreateWire(cv "route" "full" '((28.000 10.999) (28.750 10.999)) 0 0 0 nil nil)
schCreateWireLabel(cv nil '(28.250 10.999) "IB" "lowerLeft" "R0" "stick" 0.0625 nil)
schCreatePin(cv nil "IB" "inputOutput" nil '(28.750 10.999) "R180")
schCreateWire(cv "route" "full" '((27.125 10.938) (26.375 10.938)) 0 0 0 nil nil)
schCreateWireLabel(cv nil '(26.875 10.938) "GNDCMP" "lowerRight" "R0" "stick" 0.0625 nil)
schCreateWire(cv "route" "full" '((27.125 11.312) (26.375 11.312)) 0 0 0 nil nil)
schCreateWireLabel(cv nil '(26.875 11.312) "GIOL" "lowerRight" "R0" "stick" 0.0625 nil)
schCreateWire(cv "route" "full" '((27.125 10.562) (26.375 10.562)) 0 0 0 nil nil)
schCreateWireLabel(cv nil '(26.875 10.562) "VDDCMP" "lowerRight" "R0" "stick" 0.0625 nil)
dbCreateInst(cv pvdd1ac_h_gMaster "VDDDIG_right5" '(28.0 13.1875) "R90")
schCreateWire(cv "route" "full" '((27.125 12.938) (26.375 12.938)) 0 0 0 nil nil)
schCreateWireLabel(cv nil '(26.875 12.938) "GNDCMP" "lowerRight" "R0" "stick" 0.0625 nil)
schCreateWire(cv "route" "full" '((27.125 13.312) (26.375 13.312)) 0 0 0 nil nil)
schCreateWireLabel(cv nil '(26.875 13.312) "GIOL" "lowerRight" "R0" "stick" 0.0625 nil)
schCreateWire(cv "route" "full" '((28.000 12.999) (28.750 12.999)) 0 0 0 nil nil)
schCreateWireLabel(cv nil '(28.250 12.999) "VDDDIG" "lowerLeft" "R0" "stick" 0.0625 nil)
schCreatePin(cv nil "VDDDIG" "inputOutput" nil '(28.750 12.999) "R180")
schCreateWire(cv "route" "full" '((27.125 12.562) (26.375 12.562)) 0 0 0 nil nil)
schCreateWireLabel(cv nil '(26.875 12.562) "VDDCMP" "lowerRight" "R0" "stick" 0.0625 nil)
dbCreateInst(cv pvss1ac_h_gMaster "GNDDIG_right6" '(28.0 15.1875) "R90")
schCreateWire(cv "route" "full" '((28.000 14.999) (28.750 14.999)) 0 0 0 nil nil)
schCreateWireLabel(cv nil '(28.250 14.999) "GNDDIG" "lowerLeft" "R0" "stick" 0.0625 nil)
schCreatePin(cv nil "GNDDIG" "inputOutput" nil '(28.750 14.999) "R180")
schCreateWire(cv "route" "full" '((27.125 14.938) (26.375 14.938)) 0 0 0 nil nil)
schCreateWireLabel(cv nil '(26.875 14.938) "GNDCMP" "lowerRight" "R0" "stick" 0.0625 nil)
schCreateWire(cv "route" "full" '((27.125 15.312) (26.375 15.312)) 0 0 0 nil nil)
schCreateWireLabel(cv nil '(26.875 15.312) "GIOL" "lowerRight" "R0" "stick" 0.0625 nil)
schCreateWire(cv "route" "full" '((27.125 14.562) (26.375 14.562)) 0 0 0 nil nil)
schCreateWireLabel(cv nil '(26.875 14.562) "VDDCMP" "lowerRight" "R0" "stick" 0.0625 nil)
pvss1dgz_h_gMaster = dbOpenCellView("tphn28hpcpgv18" "PVSS1DGZ_H_G" "symbol")
dbCreateInst(cv pvss1dgz_h_gMaster "GIOL_right7" '(28.0 16.0) "R90")
schCreateWire(cv "route" "full" '((27.000 16.375) (26.250 16.375)) 0 0 0 nil nil)
schCreateWireLabel(cv nil '(26.750 16.375) "POC" "lowerRight" "R0" "stick" 0.0625 nil)
schCreateWire(cv "route" "full" '((27.000 16.562) (26.250 16.562)) 0 0 0 nil nil)
schCreateWireLabel(cv nil '(26.750 16.562) "VIOL" "lowerRight" "R0" "stick" 0.0625 nil)
schCreateWire(cv "route" "full" '((28.000 17.000) (28.750 17.000)) 0 0 0 nil nil)
schCreateWireLabel(cv nil '(28.250 17.000) "GIOL" "lowerLeft" "R0" "stick" 0.0625 nil)
schCreatePin(cv nil "GIOL" "inputOutput" nil '(28.750 17.000) "R180")
schCreateWire(cv "route" "full" '((27.000 16.938) (26.250 16.938)) 0 0 0 nil nil)
schCreateWireLabel(cv nil '(26.750 16.938) "VIOH" "lowerRight" "R0" "stick" 0.0625 nil)
schCreateWire(cv "route" "full" '((27.000 17.312) (26.250 17.312)) 0 0 0 nil nil)
schCreateWireLabel(cv nil '(26.750 17.312) "GIOH" "lowerRight" "R0" "stick" 0.0625 nil)
pddw16sdgz_h_gMaster = dbOpenCellView("tphn28hpcpgv18" "PDDW16SDGZ_H_G" "symbol")
dbCreateInst(cv pddw16sdgz_h_gMaster "SLP_right8" '(28.0 18.3125) "R90")
schCreateWire(cv "route" "full" '((27.000 18.438) (26.250 18.438)) 0 0 0 nil nil)
schCreateWireLabel(cv nil '(26.750 18.438) "GIOL" "lowerRight" "R0" "stick" 0.0625 nil)
schCreateWire(cv "route" "full" '((27.000 18.562) (26.250 18.562)) 0 0 0 nil nil)
schCreateWireLabel(cv nil '(26.750 18.562) "SLP_CORE" "lowerRight" "R0" "stick" 0.0625 nil)
schCreatePin(cv nil "SLP_CORE" "inputOutput" nil '(26.250 18.562) "R0")
schCreateWire(cv "route" "full" '((27.000 18.188) (26.250 18.188)) 0 0 0 nil nil)
schCreateWireLabel(cv nil '(26.750 18.188) "VIOL" "lowerRight" "R0" "stick" 0.0625 nil)
schCreateWire(cv "route" "full" '((27.000 18.062) (26.250 18.062)) 0 0 0 nil nil)
schCreateWireLabel(cv nil '(26.750 18.062) "GIOL" "lowerRight" "R0" "stick" 0.0625 nil)
schCreateWire(cv "route" "full" '((28.000 19.000) (28.750 19.000)) 0 0 0 nil nil)
schCreateWireLabel(cv nil '(28.250 19.000) "SLP" "lowerLeft" "R0" "stick" 0.0625 nil)
schCreatePin(cv nil "SLP" "inputOutput" nil '(28.750 19.000) "R180")
schCreateWire(cv "route" "full" '((27.000 18.688) (26.250 18.688)) 0 0 0 nil nil)
schCreateWireLabel(cv nil '(26.750 18.688) "POC" "lowerRight" "R0" "stick" 0.0625 nil)
schCreateWire(cv "route" "full" '((27.000 18.875) (26.250 18.875)) 0 0 0 nil nil)
schCreateWireLabel(cv nil '(26.750 18.875) "VIOL" "lowerRight" "R0" "stick" 0.0625 nil)
schCreateWire(cv "route" "full" '((27.000 19.062) (26.250 19.062)) 0 0 0 nil nil)
schCreateWireLabel(cv nil '(26.750 19.062) "GIOL" "lowerRight" "R0" "stick" 0.0625 nil)
schCreateWire(cv "route" "full" '((27.000 19.250) (26.250 19.250)) 0 0 0 nil nil)
schCreateWireLabel(cv nil '(26.750 19.250) "VIOH" "lowerRight" "R0" "stick" 0.0625 nil)
schCreateWire(cv "route" "full" '((27.000 19.625) (26.250 19.625)) 0 0 0 nil nil)
schCreateWireLabel(cv nil '(26.750 19.625) "GIOH" "lowerRight" "R0" "stick" 0.0625 nil)
dbCreateInst(cv pddw16sdgz_h_gMaster "SDI_right9" '(28.0 20.3125) "R90")
schCreateWire(cv "route" "full" '((27.000 20.438) (26.250 20.438)) 0 0 0 nil nil)
schCreateWireLabel(cv nil '(26.750 20.438) "GIOL" "lowerRight" "R0" "stick" 0.0625 nil)
schCreateWire(cv "route" "full" '((27.000 20.562) (26.250 20.562)) 0 0 0 nil nil)
schCreateWireLabel(cv nil '(26.750 20.562) "SDI_CORE" "lowerRight" "R0" "stick" 0.0625 nil)
schCreatePin(cv nil "SDI_CORE" "inputOutput" nil '(26.250 20.562) "R0")
schCreateWire(cv "route" "full" '((27.000 20.188) (26.250 20.188)) 0 0 0 nil nil)
schCreateWireLabel(cv nil '(26.750 20.188) "VIOL" "lowerRight" "R0" "stick" 0.0625 nil)
schCreateWire(cv "route" "full" '((27.000 20.062) (26.250 20.062)) 0 0 0 nil nil)
schCreateWireLabel(cv nil '(26.750 20.062) "GIOL" "lowerRight" "R0" "stick" 0.0625 nil)
schCreateWire(cv "route" "full" '((28.000 21.000) (28.750 21.000)) 0 0 0 nil nil)
schCreateWireLabel(cv nil '(28.250 21.000) "SDI" "lowerLeft" "R0" "stick" 0.0625 nil)
schCreatePin(cv nil "SDI" "inputOutput" nil '(28.750 21.000) "R180")
schCreateWire(cv "route" "full" '((27.000 20.688) (26.250 20.688)) 0 0 0 nil nil)
schCreateWireLabel(cv nil '(26.750 20.688) "POC" "lowerRight" "R0" "stick" 0.0625 nil)
schCreateWire(cv "route" "full" '((27.000 20.875) (26.250 20.875)) 0 0 0 nil nil)
schCreateWireLabel(cv nil '(26.750 20.875) "VIOL" "lowerRight" "R0" "stick" 0.0625 nil)
schCreateWire(cv "route" "full" '((27.000 21.062) (26.250 21.062)) 0 0 0 nil nil)
schCreateWireLabel(cv nil '(26.750 21.062) "GIOL" "lowerRight" "R0" "stick" 0.0625 nil)
schCreateWire(cv "route" "full" '((27.000 21.250) (26.250 21.250)) 0 0 0 nil nil)
schCreateWireLabel(cv nil '(26.750 21.250) "VIOH" "lowerRight" "R0" "stick" 0.0625 nil)
schCreateWire(cv "route" "full" '((27.000 21.625) (26.250 21.625)) 0 0 0 nil nil)
schCreateWireLabel(cv nil '(26.750 21.625) "GIOH" "lowerRight" "R0" "stick" 0.0625 nil)
dbCreateInst(cv pddw16sdgz_h_gMaster "SCK_right10" '(28.0 22.3125) "R90")
schCreateWire(cv "route" "full" '((27.000 22.438) (26.250 22.438)) 0 0 0 nil nil)
schCreateWireLabel(cv nil '(26.750 22.438) "GIOL" "lowerRight" "R0" "stick" 0.0625 nil)
schCreateWire(cv "route" "full" '((27.000 22.562) (26.250 22.562)) 0 0 0 nil nil)
schCreateWireLabel(cv nil '(26.750 22.562) "SCK_CORE" "lowerRight" "R0" "stick" 0.0625 nil)
schCreatePin(cv nil "SCK_CORE" "inputOutput" nil '(26.250 22.562) "R0")
schCreateWire(cv "route" "full" '((27.000 22.188) (26.250 22.188)) 0 0 0 nil nil)
schCreateWireLabel(cv nil '(26.750 22.188) "VIOL" "lowerRight" "R0" "stick" 0.0625 nil)
schCreateWire(cv "route" "full" '((27.000 22.062) (26.250 22.062)) 0 0 0 nil nil)
schCreateWireLabel(cv nil '(26.750 22.062) "GIOL" "lowerRight" "R0" "stick" 0.0625 nil)
schCreateWire(cv "route" "full" '((28.000 23.000) (28.750 23.000)) 0 0 0 nil nil)
schCreateWireLabel(cv nil '(28.250 23.000) "SCK" "lowerLeft" "R0" "stick" 0.0625 nil)
schCreatePin(cv nil "SCK" "inputOutput" nil '(28.750 23.000) "R180")
schCreateWire(cv "route" "full" '((27.000 22.688) (26.250 22.688)) 0 0 0 nil nil)
schCreateWireLabel(cv nil '(26.750 22.688) "POC" "lowerRight" "R0" "stick" 0.0625 nil)
schCreateWire(cv "route" "full" '((27.000 22.875) (26.250 22.875)) 0 0 0 nil nil)
schCreateWireLabel(cv nil '(26.750 22.875) "VIOL" "lowerRight" "R0" "stick" 0.0625 nil)
schCreateWire(cv "route" "full" '((27.000 23.062) (26.250 23.062)) 0 0 0 nil nil)
schCreateWireLabel(cv nil '(26.750 23.062) "GIOL" "lowerRight" "R0" "stick" 0.0625 nil)
schCreateWire(cv "route" "full" '((27.000 23.250) (26.250 23.250)) 0 0 0 nil nil)
schCreateWireLabel(cv nil '(26.750 23.250) "VIOH" "lowerRight" "R0" "stick" 0.0625 nil)
schCreateWire(cv "route" "full" '((27.000 23.625) (26.250 23.625)) 0 0 0 nil nil)
schCreateWireLabel(cv nil '(26.750 23.625) "GIOH" "lowerRight" "R0" "stick" 0.0625 nil)
dbCreateInst(cv pddw16sdgz_h_gMaster "SDO_right11" '(28.0 24.3125) "R90")
schCreateWire(cv "route" "full" '((27.000 24.438) (26.250 24.438)) 0 0 0 nil nil)
schCreateWireLabel(cv nil '(26.750 24.438) "GIOL" "lowerRight" "R0" "stick" 0.0625 nil)
schCreateWire(cv "route" "full" '((27.000 24.562) (26.250 24.562)) 0 0 0 nil nil)
schCreateWireLabel(cv nil '(26.750 24.562) "SDO_CORE" "lowerRight" "R0" "stick" 0.0625 nil)
schCreatePin(cv nil "SDO_CORE" "inputOutput" nil '(26.250 24.562) "R0")
schCreateWire(cv "route" "full" '((27.000 24.188) (26.250 24.188)) 0 0 0 nil nil)
schCreateWireLabel(cv nil '(26.750 24.188) "VIOL" "lowerRight" "R0" "stick" 0.0625 nil)
schCreateWire(cv "route" "full" '((27.000 24.062) (26.250 24.062)) 0 0 0 nil nil)
schCreateWireLabel(cv nil '(26.750 24.062) "GIOL" "lowerRight" "R0" "stick" 0.0625 nil)
schCreateWire(cv "route" "full" '((28.000 25.000) (28.750 25.000)) 0 0 0 nil nil)
schCreateWireLabel(cv nil '(28.250 25.000) "SDO" "lowerLeft" "R0" "stick" 0.0625 nil)
schCreatePin(cv nil "SDO" "inputOutput" nil '(28.750 25.000) "R180")
schCreateWire(cv "route" "full" '((27.000 24.688) (26.250 24.688)) 0 0 0 nil nil)
schCreateWireLabel(cv nil '(26.750 24.688) "POC" "lowerRight" "R0" "stick" 0.0625 nil)
schCreateWire(cv "route" "full" '((27.000 24.875) (26.250 24.875)) 0 0 0 nil nil)
schCreateWireLabel(cv nil '(26.750 24.875) "VIOL" "lowerRight" "R0" "stick" 0.0625 nil)
schCreateWire(cv "route" "full" '((27.000 25.062) (26.250 25.062)) 0 0 0 nil nil)
schCreateWireLabel(cv nil '(26.750 25.062) "GIOL" "lowerRight" "R0" "stick" 0.0625 nil)
schCreateWire(cv "route" "full" '((27.000 25.250) (26.250 25.250)) 0 0 0 nil nil)
schCreateWireLabel(cv nil '(26.750 25.250) "VIOH" "lowerRight" "R0" "stick" 0.0625 nil)
schCreateWire(cv "route" "full" '((27.000 25.625) (26.250 25.625)) 0 0 0 nil nil)
schCreateWireLabel(cv nil '(26.750 25.625) "GIOH" "lowerRight" "R0" "stick" 0.0625 nil)
dbCreateInst(cv pddw16sdgz_h_gMaster "RST_right12" '(28.0 26.3125) "R90")
schCreateWire(cv "route" "full" '((27.000 26.438) (26.250 26.438)) 0 0 0 nil nil)
schCreateWireLabel(cv nil '(26.750 26.438) "GIOL" "lowerRight" "R0" "stick" 0.0625 nil)
schCreateWire(cv "route" "full" '((27.000 26.562) (26.250 26.562)) 0 0 0 nil nil)
schCreateWireLabel(cv nil '(26.750 26.562) "RST_CORE" "lowerRight" "R0" "stick" 0.0625 nil)
schCreatePin(cv nil "RST_CORE" "inputOutput" nil '(26.250 26.562) "R0")
schCreateWire(cv "route" "full" '((27.000 26.188) (26.250 26.188)) 0 0 0 nil nil)
schCreateWireLabel(cv nil '(26.750 26.188) "VIOL" "lowerRight" "R0" "stick" 0.0625 nil)
schCreateWire(cv "route" "full" '((27.000 26.062) (26.250 26.062)) 0 0 0 nil nil)
schCreateWireLabel(cv nil '(26.750 26.062) "GIOL" "lowerRight" "R0" "stick" 0.0625 nil)
schCreateWire(cv "route" "full" '((28.000 27.000) (28.750 27.000)) 0 0 0 nil nil)
schCreateWireLabel(cv nil '(28.250 27.000) "RST" "lowerLeft" "R0" "stick" 0.0625 nil)
schCreatePin(cv nil "RST" "inputOutput" nil '(28.750 27.000) "R180")
schCreateWire(cv "route" "full" '((27.000 26.688) (26.250 26.688)) 0 0 0 nil nil)
schCreateWireLabel(cv nil '(26.750 26.688) "POC" "lowerRight" "R0" "stick" 0.0625 nil)
schCreateWire(cv "route" "full" '((27.000 26.875) (26.250 26.875)) 0 0 0 nil nil)
schCreateWireLabel(cv nil '(26.750 26.875) "VIOL" "lowerRight" "R0" "stick" 0.0625 nil)
schCreateWire(cv "route" "full" '((27.000 27.062) (26.250 27.062)) 0 0 0 nil nil)
schCreateWireLabel(cv nil '(26.750 27.062) "GIOL" "lowerRight" "R0" "stick" 0.0625 nil)
schCreateWire(cv "route" "full" '((27.000 27.250) (26.250 27.250)) 0 0 0 nil nil)
schCreateWireLabel(cv nil '(26.750 27.250) "VIOH" "lowerRight" "R0" "stick" 0.0625 nil)
schCreateWire(cv "route" "full" '((27.000 27.625) (26.250 27.625)) 0 0 0 nil nil)
schCreateWireLabel(cv nil '(26.750 27.625) "GIOH" "lowerRight" "R0" "stick" 0.0625 nil)
dbCreateInst(cv pddw16sdgz_h_gMaster "SYNC_right13" '(28.0 28.3125) "R90")
schCreateWire(cv "route" "full" '((27.000 28.438) (26.250 28.438)) 0 0 0 nil nil)
schCreateWireLabel(cv nil '(26.750 28.438) "GIOL" "lowerRight" "R0" "stick" 0.0625 nil)
schCreateWire(cv "route" "full" '((27.000 28.562) (26.250 28.562)) 0 0 0 nil nil)
schCreateWireLabel(cv nil '(26.750 28.562) "SYNC_CORE" "lowerRight" "R0" "stick" 0.0625 nil)
schCreatePin(cv nil "SYNC_CORE" "inputOutput" nil '(26.250 28.562) "R0")
schCreateWire(cv "route" "full" '((27.000 28.188) (26.250 28.188)) 0 0 0 nil nil)
schCreateWireLabel(cv nil '(26.750 28.188) "VIOL" "lowerRight" "R0" "stick" 0.0625 nil)
schCreateWire(cv "route" "full" '((27.000 28.062) (26.250 28.062)) 0 0 0 nil nil)
schCreateWireLabel(cv nil '(26.750 28.062) "GIOL" "lowerRight" "R0" "stick" 0.0625 nil)
schCreateWire(cv "route" "full" '((28.000 29.000) (28.750 29.000)) 0 0 0 nil nil)
schCreateWireLabel(cv nil '(28.250 29.000) "SYNC" "lowerLeft" "R0" "stick" 0.0625 nil)
schCreatePin(cv nil "SYNC" "inputOutput" nil '(28.750 29.000) "R180")
schCreateWire(cv "route" "full" '((27.000 28.688) (26.250 28.688)) 0 0 0 nil nil)
schCreateWireLabel(cv nil '(26.750 28.688) "POC" "lowerRight" "R0" "stick" 0.0625 nil)
schCreateWire(cv "route" "full" '((27.000 28.875) (26.250 28.875)) 0 0 0 nil nil)
schCreateWireLabel(cv nil '(26.750 28.875) "VIOL" "lowerRight" "R0" "stick" 0.0625 nil)
schCreateWire(cv "route" "full" '((27.000 29.062) (26.250 29.062)) 0 0 0 nil nil)
schCreateWireLabel(cv nil '(26.750 29.062) "GIOL" "lowerRight" "R0" "stick" 0.0625 nil)
schCreateWire(cv "route" "full" '((27.000 29.250) (26.250 29.250)) 0 0 0 nil nil)
schCreateWireLabel(cv nil '(26.750 29.250) "VIOH" "lowerRight" "R0" "stick" 0.0625 nil)
schCreateWire(cv "route" "full" '((27.000 29.625) (26.250 29.625)) 0 0 0 nil nil)
schCreateWireLabel(cv nil '(26.750 29.625) "GIOH" "lowerRight" "R0" "stick" 0.0625 nil)
dbCreateInst(cv pddw16sdgz_h_gMaster "D0_right14" '(28.0 30.3125) "R90")
schCreateWire(cv "route" "full" '((27.000 30.438) (26.250 30.438)) 0 0 0 nil nil)
schCreateWireLabel(cv nil '(26.750 30.438) "GIOL" "lowerRight" "R0" "stick" 0.0625 nil)
schCreateWire(cv "route" "full" '((27.000 30.562) (26.250 30.562)) 0 0 0 nil nil)
schCreateWireLabel(cv nil '(26.750 30.562) "D0_CORE" "lowerRight" "R0" "stick" 0.0625 nil)
schCreatePin(cv nil "D0_CORE" "inputOutput" nil '(26.250 30.562) "R0")
schCreateWire(cv "route" "full" '((27.000 30.188) (26.250 30.188)) 0 0 0 nil nil)
schCreateWireLabel(cv nil '(26.750 30.188) "VIOL" "lowerRight" "R0" "stick" 0.0625 nil)
schCreateWire(cv "route" "full" '((27.000 30.062) (26.250 30.062)) 0 0 0 nil nil)
schCreateWireLabel(cv nil '(26.750 30.062) "GIOL" "lowerRight" "R0" "stick" 0.0625 nil)
schCreateWire(cv "route" "full" '((28.000 31.000) (28.750 31.000)) 0 0 0 nil nil)
schCreateWireLabel(cv nil '(28.250 31.000) "D0" "lowerLeft" "R0" "stick" 0.0625 nil)
schCreatePin(cv nil "D0" "inputOutput" nil '(28.750 31.000) "R180")
schCreateWire(cv "route" "full" '((27.000 30.688) (26.250 30.688)) 0 0 0 nil nil)
schCreateWireLabel(cv nil '(26.750 30.688) "POC" "lowerRight" "R0" "stick" 0.0625 nil)
schCreateWire(cv "route" "full" '((27.000 30.875) (26.250 30.875)) 0 0 0 nil nil)
schCreateWireLabel(cv nil '(26.750 30.875) "VIOL" "lowerRight" "R0" "stick" 0.0625 nil)
schCreateWire(cv "route" "full" '((27.000 31.062) (26.250 31.062)) 0 0 0 nil nil)
schCreateWireLabel(cv nil '(26.750 31.062) "GIOL" "lowerRight" "R0" "stick" 0.0625 nil)
schCreateWire(cv "route" "full" '((27.000 31.250) (26.250 31.250)) 0 0 0 nil nil)
schCreateWireLabel(cv nil '(26.750 31.250) "VIOH" "lowerRight" "R0" "stick" 0.0625 nil)
schCreateWire(cv "route" "full" '((27.000 31.625) (26.250 31.625)) 0 0 0 nil nil)
schCreateWireLabel(cv nil '(26.750 31.625) "GIOH" "lowerRight" "R0" "stick" 0.0625 nil)
dbCreateInst(cv pddw16sdgz_h_gMaster "D1_right15" '(28.0 32.3125) "R90")
schCreateWire(cv "route" "full" '((27.000 32.438) (26.250 32.438)) 0 0 0 nil nil)
schCreateWireLabel(cv nil '(26.750 32.438) "GIOL" "lowerRight" "R0" "stick" 0.0625 nil)
schCreateWire(cv "route" "full" '((27.000 32.562) (26.250 32.562)) 0 0 0 nil nil)
schCreateWireLabel(cv nil '(26.750 32.562) "D1_CORE" "lowerRight" "R0" "stick" 0.0625 nil)
schCreatePin(cv nil "D1_CORE" "inputOutput" nil '(26.250 32.562) "R0")
schCreateWire(cv "route" "full" '((27.000 32.188) (26.250 32.188)) 0 0 0 nil nil)
schCreateWireLabel(cv nil '(26.750 32.188) "VIOL" "lowerRight" "R0" "stick" 0.0625 nil)
schCreateWire(cv "route" "full" '((27.000 32.062) (26.250 32.062)) 0 0 0 nil nil)
schCreateWireLabel(cv nil '(26.750 32.062) "GIOL" "lowerRight" "R0" "stick" 0.0625 nil)
schCreateWire(cv "route" "full" '((28.000 33.001) (28.750 33.001)) 0 0 0 nil nil)
schCreateWireLabel(cv nil '(28.250 33.001) "D1" "lowerLeft" "R0" "stick" 0.0625 nil)
schCreatePin(cv nil "D1" "inputOutput" nil '(28.750 33.001) "R180")
schCreateWire(cv "route" "full" '((27.000 32.688) (26.250 32.688)) 0 0 0 nil nil)
schCreateWireLabel(cv nil '(26.750 32.688) "POC" "lowerRight" "R0" "stick" 0.0625 nil)
schCreateWire(cv "route" "full" '((27.000 32.874) (26.250 32.874)) 0 0 0 nil nil)
schCreateWireLabel(cv nil '(26.750 32.874) "VIOL" "lowerRight" "R0" "stick" 0.0625 nil)
schCreateWire(cv "route" "full" '((27.000 33.062) (26.250 33.062)) 0 0 0 nil nil)
schCreateWireLabel(cv nil '(26.750 33.062) "GIOL" "lowerRight" "R0" "stick" 0.0625 nil)
schCreateWire(cv "route" "full" '((27.000 33.251) (26.250 33.251)) 0 0 0 nil nil)
schCreateWireLabel(cv nil '(26.750 33.251) "VIOH" "lowerRight" "R0" "stick" 0.0625 nil)
schCreateWire(cv "route" "full" '((27.000 33.624) (26.250 33.624)) 0 0 0 nil nil)
schCreateWireLabel(cv nil '(26.750 33.624) "GIOH" "lowerRight" "R0" "stick" 0.0625 nil)
dbCreateInst(cv pddw16sdgz_h_gMaster "D2_right16" '(28.0 34.3125) "R90")
schCreateWire(cv "route" "full" '((27.000 34.438) (26.250 34.438)) 0 0 0 nil nil)
schCreateWireLabel(cv nil '(26.750 34.438) "GIOL" "lowerRight" "R0" "stick" 0.0625 nil)
schCreateWire(cv "route" "full" '((27.000 34.562) (26.250 34.562)) 0 0 0 nil nil)
schCreateWireLabel(cv nil '(26.750 34.562) "D2_CORE" "lowerRight" "R0" "stick" 0.0625 nil)
schCreatePin(cv nil "D2_CORE" "inputOutput" nil '(26.250 34.562) "R0")
schCreateWire(cv "route" "full" '((27.000 34.188) (26.250 34.188)) 0 0 0 nil nil)
schCreateWireLabel(cv nil '(26.750 34.188) "VIOL" "lowerRight" "R0" "stick" 0.0625 nil)
schCreateWire(cv "route" "full" '((27.000 34.062) (26.250 34.062)) 0 0 0 nil nil)
schCreateWireLabel(cv nil '(26.750 34.062) "GIOL" "lowerRight" "R0" "stick" 0.0625 nil)
schCreateWire(cv "route" "full" '((28.000 35.001) (28.750 35.001)) 0 0 0 nil nil)
schCreateWireLabel(cv nil '(28.250 35.001) "D2" "lowerLeft" "R0" "stick" 0.0625 nil)
schCreatePin(cv nil "D2" "inputOutput" nil '(28.750 35.001) "R180")
schCreateWire(cv "route" "full" '((27.000 34.688) (26.250 34.688)) 0 0 0 nil nil)
schCreateWireLabel(cv nil '(26.750 34.688) "POC" "lowerRight" "R0" "stick" 0.0625 nil)
schCreateWire(cv "route" "full" '((27.000 34.874) (26.250 34.874)) 0 0 0 nil nil)
schCreateWireLabel(cv nil '(26.750 34.874) "VIOL" "lowerRight" "R0" "stick" 0.0625 nil)
schCreateWire(cv "route" "full" '((27.000 35.062) (26.250 35.062)) 0 0 0 nil nil)
schCreateWireLabel(cv nil '(26.750 35.062) "GIOL" "lowerRight" "R0" "stick" 0.0625 nil)
schCreateWire(cv "route" "full" '((27.000 35.251) (26.250 35.251)) 0 0 0 nil nil)
schCreateWireLabel(cv nil '(26.750 35.251) "VIOH" "lowerRight" "R0" "stick" 0.0625 nil)
schCreateWire(cv "route" "full" '((27.000 35.624) (26.250 35.624)) 0 0 0 nil nil)
schCreateWireLabel(cv nil '(26.750 35.624) "GIOH" "lowerRight" "R0" "stick" 0.0625 nil)
dbCreateInst(cv pddw16sdgz_h_gMaster "D3_right17" '(28.0 36.3125) "R90")
schCreateWire(cv "route" "full" '((27.000 36.438) (26.250 36.438)) 0 0 0 nil nil)
schCreateWireLabel(cv nil '(26.750 36.438) "GIOL" "lowerRight" "R0" "stick" 0.0625 nil)
schCreateWire(cv "route" "full" '((27.000 36.562) (26.250 36.562)) 0 0 0 nil nil)
schCreateWireLabel(cv nil '(26.750 36.562) "D3_CORE" "lowerRight" "R0" "stick" 0.0625 nil)
schCreatePin(cv nil "D3_CORE" "inputOutput" nil '(26.250 36.562) "R0")
schCreateWire(cv "route" "full" '((27.000 36.188) (26.250 36.188)) 0 0 0 nil nil)
schCreateWireLabel(cv nil '(26.750 36.188) "VIOL" "lowerRight" "R0" "stick" 0.0625 nil)
schCreateWire(cv "route" "full" '((27.000 36.062) (26.250 36.062)) 0 0 0 nil nil)
schCreateWireLabel(cv nil '(26.750 36.062) "GIOL" "lowerRight" "R0" "stick" 0.0625 nil)
schCreateWire(cv "route" "full" '((28.000 37.001) (28.750 37.001)) 0 0 0 nil nil)
schCreateWireLabel(cv nil '(28.250 37.001) "D3" "lowerLeft" "R0" "stick" 0.0625 nil)
schCreatePin(cv nil "D3" "inputOutput" nil '(28.750 37.001) "R180")
schCreateWire(cv "route" "full" '((27.000 36.688) (26.250 36.688)) 0 0 0 nil nil)
schCreateWireLabel(cv nil '(26.750 36.688) "POC" "lowerRight" "R0" "stick" 0.0625 nil)
schCreateWire(cv "route" "full" '((27.000 36.874) (26.250 36.874)) 0 0 0 nil nil)
schCreateWireLabel(cv nil '(26.750 36.874) "VIOL" "lowerRight" "R0" "stick" 0.0625 nil)
schCreateWire(cv "route" "full" '((27.000 37.062) (26.250 37.062)) 0 0 0 nil nil)
schCreateWireLabel(cv nil '(26.750 37.062) "GIOL" "lowerRight" "R0" "stick" 0.0625 nil)
schCreateWire(cv "route" "full" '((27.000 37.251) (26.250 37.251)) 0 0 0 nil nil)
schCreateWireLabel(cv nil '(26.750 37.251) "VIOH" "lowerRight" "R0" "stick" 0.0625 nil)
schCreateWire(cv "route" "full" '((27.000 37.624) (26.250 37.624)) 0 0 0 nil nil)
schCreateWireLabel(cv nil '(26.750 37.624) "GIOH" "lowerRight" "R0" "stick" 0.0625 nil)
dbCreateInst(cv pddw16sdgz_h_gMaster "D4_right18" '(28.0 38.3125) "R90")
schCreateWire(cv "route" "full" '((27.000 38.438) (26.250 38.438)) 0 0 0 nil nil)
schCreateWireLabel(cv nil '(26.750 38.438) "GIOL" "lowerRight" "R0" "stick" 0.0625 nil)
schCreateWire(cv "route" "full" '((27.000 38.562) (26.250 38.562)) 0 0 0 nil nil)
schCreateWireLabel(cv nil '(26.750 38.562) "D4_CORE" "lowerRight" "R0" "stick" 0.0625 nil)
schCreatePin(cv nil "D4_CORE" "inputOutput" nil '(26.250 38.562) "R0")
schCreateWire(cv "route" "full" '((27.000 38.188) (26.250 38.188)) 0 0 0 nil nil)
schCreateWireLabel(cv nil '(26.750 38.188) "VIOL" "lowerRight" "R0" "stick" 0.0625 nil)
schCreateWire(cv "route" "full" '((27.000 38.062) (26.250 38.062)) 0 0 0 nil nil)
schCreateWireLabel(cv nil '(26.750 38.062) "GIOL" "lowerRight" "R0" "stick" 0.0625 nil)
schCreateWire(cv "route" "full" '((28.000 39.001) (28.750 39.001)) 0 0 0 nil nil)
schCreateWireLabel(cv nil '(28.250 39.001) "D4" "lowerLeft" "R0" "stick" 0.0625 nil)
schCreatePin(cv nil "D4" "inputOutput" nil '(28.750 39.001) "R180")
schCreateWire(cv "route" "full" '((27.000 38.688) (26.250 38.688)) 0 0 0 nil nil)
schCreateWireLabel(cv nil '(26.750 38.688) "POC" "lowerRight" "R0" "stick" 0.0625 nil)
schCreateWire(cv "route" "full" '((27.000 38.874) (26.250 38.874)) 0 0 0 nil nil)
schCreateWireLabel(cv nil '(26.750 38.874) "VIOL" "lowerRight" "R0" "stick" 0.0625 nil)
schCreateWire(cv "route" "full" '((27.000 39.062) (26.250 39.062)) 0 0 0 nil nil)
schCreateWireLabel(cv nil '(26.750 39.062) "GIOL" "lowerRight" "R0" "stick" 0.0625 nil)
schCreateWire(cv "route" "full" '((27.000 39.251) (26.250 39.251)) 0 0 0 nil nil)
schCreateWireLabel(cv nil '(26.750 39.251) "VIOH" "lowerRight" "R0" "stick" 0.0625 nil)
schCreateWire(cv "route" "full" '((27.000 39.624) (26.250 39.624)) 0 0 0 nil nil)
schCreateWireLabel(cv nil '(26.750 39.624) "GIOH" "lowerRight" "R0" "stick" 0.0625 nil)
dbCreateInst(cv pddw16sdgz_h_gMaster "DCLK_right19" '(28.0 40.3125) "R90")
schCreateWire(cv "route" "full" '((27.000 40.438) (26.250 40.438)) 0 0 0 nil nil)
schCreateWireLabel(cv nil '(26.750 40.438) "GIOL" "lowerRight" "R0" "stick" 0.0625 nil)
schCreateWire(cv "route" "full" '((27.000 40.562) (26.250 40.562)) 0 0 0 nil nil)
schCreateWireLabel(cv nil '(26.750 40.562) "DCLK_CORE" "lowerRight" "R0" "stick" 0.0625 nil)
schCreatePin(cv nil "DCLK_CORE" "inputOutput" nil '(26.250 40.562) "R0")
schCreateWire(cv "route" "full" '((27.000 40.188) (26.250 40.188)) 0 0 0 nil nil)
schCreateWireLabel(cv nil '(26.750 40.188) "VIOL" "lowerRight" "R0" "stick" 0.0625 nil)
schCreateWire(cv "route" "full" '((27.000 40.062) (26.250 40.062)) 0 0 0 nil nil)
schCreateWireLabel(cv nil '(26.750 40.062) "GIOL" "lowerRight" "R0" "stick" 0.0625 nil)
schCreateWire(cv "route" "full" '((28.000 41.001) (28.750 41.001)) 0 0 0 nil nil)
schCreateWireLabel(cv nil '(28.250 41.001) "DCLK" "lowerLeft" "R0" "stick" 0.0625 nil)
schCreatePin(cv nil "DCLK" "inputOutput" nil '(28.750 41.001) "R180")
schCreateWire(cv "route" "full" '((27.000 40.688) (26.250 40.688)) 0 0 0 nil nil)
schCreateWireLabel(cv nil '(26.750 40.688) "POC" "lowerRight" "R0" "stick" 0.0625 nil)
schCreateWire(cv "route" "full" '((27.000 40.874) (26.250 40.874)) 0 0 0 nil nil)
schCreateWireLabel(cv nil '(26.750 40.874) "VIOL" "lowerRight" "R0" "stick" 0.0625 nil)
schCreateWire(cv "route" "full" '((27.000 41.062) (26.250 41.062)) 0 0 0 nil nil)
schCreateWireLabel(cv nil '(26.750 41.062) "GIOL" "lowerRight" "R0" "stick" 0.0625 nil)
schCreateWire(cv "route" "full" '((27.000 41.251) (26.250 41.251)) 0 0 0 nil nil)
schCreateWireLabel(cv nil '(26.750 41.251) "VIOH" "lowerRight" "R0" "stick" 0.0625 nil)
schCreateWire(cv "route" "full" '((27.000 41.624) (26.250 41.624)) 0 0 0 nil nil)
schCreateWireLabel(cv nil '(26.750 41.624) "GIOH" "lowerRight" "R0" "stick" 0.0625 nil)
pddw16sdgz_v_gMaster = dbOpenCellView("tphn28hpcpgv18" "PDDW16SDGZ_V_G" "symbol")
dbCreateInst(cv pddw16sdgz_v_gMaster "SRAM_top0" '(25.6875 44.0) "R180")
schCreateWire(cv "route" "full" '((25.562 43.000) (25.562 42.250)) 0 0 0 nil nil)
schCreateWireLabel(cv nil '(25.562 42.750) "GIOL" "lowerRight" "R90" "stick" 0.0625 nil)
schCreateWire(cv "route" "full" '((25.438 43.000) (25.438 42.250)) 0 0 0 nil nil)
schCreateWireLabel(cv nil '(25.438 42.750) "SRAM_CORE" "lowerRight" "R90" "stick" 0.0625 nil)
schCreatePin(cv nil "SRAM_CORE" "inputOutput" nil '(25.438 42.250) "R90")
schCreateWire(cv "route" "full" '((25.812 43.000) (25.812 42.250)) 0 0 0 nil nil)
schCreateWireLabel(cv nil '(25.812 42.750) "VIOL" "lowerRight" "R90" "stick" 0.0625 nil)
schCreateWire(cv "route" "full" '((25.938 43.000) (25.938 42.250)) 0 0 0 nil nil)
schCreateWireLabel(cv nil '(25.938 42.750) "GIOL" "lowerRight" "R90" "stick" 0.0625 nil)
schCreateWire(cv "route" "full" '((25.000 44.000) (25.000 44.750)) 0 0 0 nil nil)
schCreateWireLabel(cv nil '(25.000 44.250) "SRAM" "lowerLeft" "R90" "stick" 0.0625 nil)
schCreatePin(cv nil "SRAM" "inputOutput" nil '(25.000 44.750) "R270")
schCreateWire(cv "route" "full" '((25.312 43.000) (25.312 42.250)) 0 0 0 nil nil)
schCreateWireLabel(cv nil '(25.312 42.750) "POC" "lowerRight" "R90" "stick" 0.0625 nil)
schCreateWire(cv "route" "full" '((25.125 43.000) (25.125 42.250)) 0 0 0 nil nil)
schCreateWireLabel(cv nil '(25.125 42.750) "VIOL" "lowerRight" "R90" "stick" 0.0625 nil)
schCreateWire(cv "route" "full" '((24.938 43.000) (24.938 42.250)) 0 0 0 nil nil)
schCreateWireLabel(cv nil '(24.938 42.750) "GIOL" "lowerRight" "R90" "stick" 0.0625 nil)
schCreateWire(cv "route" "full" '((24.750 43.000) (24.750 42.250)) 0 0 0 nil nil)
schCreateWireLabel(cv nil '(24.750 42.750) "VIOH" "lowerRight" "R90" "stick" 0.0625 nil)
schCreateWire(cv "route" "full" '((24.375 43.000) (24.375 42.250)) 0 0 0 nil nil)
schCreateWireLabel(cv nil '(24.375 42.750) "GIOH" "lowerRight" "R90" "stick" 0.0625 nil)
pvdd2poc_v_gMaster = dbOpenCellView("tphn28hpcpgv18" "PVDD2POC_V_G" "symbol")
dbCreateInst(cv pvdd2poc_v_gMaster "VIOH_top1" '(24.0 44.0) "R180")
schCreateWire(cv "route" "full" '((23.625 43.000) (23.625 42.250)) 0 0 0 nil nil)
schCreateWireLabel(cv nil '(23.625 42.750) "POC" "lowerRight" "R90" "stick" 0.0625 nil)
schCreateWire(cv "route" "full" '((23.438 43.000) (23.438 42.250)) 0 0 0 nil nil)
schCreateWireLabel(cv nil '(23.438 42.750) "VIOL" "lowerRight" "R90" "stick" 0.0625 nil)
schCreateWire(cv "route" "full" '((23.250 43.000) (23.250 42.250)) 0 0 0 nil nil)
schCreateWireLabel(cv nil '(23.250 42.750) "GIOL" "lowerRight" "R90" "stick" 0.0625 nil)
schCreateWire(cv "route" "full" '((23.000 44.000) (23.000 44.750)) 0 0 0 nil nil)
schCreateWireLabel(cv nil '(23.000 44.250) "VIOH" "lowerLeft" "R90" "stick" 0.0625 nil)
schCreatePin(cv nil "VIOH" "inputOutput" nil '(23.000 44.750) "R270")
schCreateWire(cv "route" "full" '((22.688 43.000) (22.688 42.250)) 0 0 0 nil nil)
schCreateWireLabel(cv nil '(22.688 42.750) "GIOH" "lowerRight" "R90" "stick" 0.0625 nil)
pvss2dgz_v_gMaster = dbOpenCellView("tphn28hpcpgv18" "PVSS2DGZ_V_G" "symbol")
dbCreateInst(cv pvss2dgz_v_gMaster "GIOH_top2" '(22.0 44.0) "R180")
schCreateWire(cv "route" "full" '((21.625 43.000) (21.625 42.250)) 0 0 0 nil nil)
schCreateWireLabel(cv nil '(21.625 42.750) "POC" "lowerRight" "R90" "stick" 0.0625 nil)
schCreateWire(cv "route" "full" '((21.438 43.000) (21.438 42.250)) 0 0 0 nil nil)
schCreateWireLabel(cv nil '(21.438 42.750) "VIOL" "lowerRight" "R90" "stick" 0.0625 nil)
schCreateWire(cv "route" "full" '((21.250 43.000) (21.250 42.250)) 0 0 0 nil nil)
schCreateWireLabel(cv nil '(21.250 42.750) "GIOL" "lowerRight" "R90" "stick" 0.0625 nil)
schCreateWire(cv "route" "full" '((21.062 43.000) (21.062 42.250)) 0 0 0 nil nil)
schCreateWireLabel(cv nil '(21.062 42.750) "VIOH" "lowerRight" "R90" "stick" 0.0625 nil)
schCreateWire(cv "route" "full" '((21.000 44.000) (21.000 44.750)) 0 0 0 nil nil)
schCreateWireLabel(cv nil '(21.000 44.250) "GIOH" "lowerLeft" "R90" "stick" 0.0625 nil)
schCreatePin(cv nil "GIOH" "inputOutput" nil '(21.000 44.750) "R270")
dbCreateInst(cv pvss2dgz_v_gMaster "GIOH_top3" '(20.0 44.0) "R180")
schCreateWire(cv "route" "full" '((19.625 43.000) (19.625 42.250)) 0 0 0 nil nil)
schCreateWireLabel(cv nil '(19.625 42.750) "POC" "lowerRight" "R90" "stick" 0.0625 nil)
schCreateWire(cv "route" "full" '((19.438 43.000) (19.438 42.250)) 0 0 0 nil nil)
schCreateWireLabel(cv nil '(19.438 42.750) "VIOL" "lowerRight" "R90" "stick" 0.0625 nil)
schCreateWire(cv "route" "full" '((19.250 43.000) (19.250 42.250)) 0 0 0 nil nil)
schCreateWireLabel(cv nil '(19.250 42.750) "GIOL" "lowerRight" "R90" "stick" 0.0625 nil)
schCreateWire(cv "route" "full" '((19.062 43.000) (19.062 42.250)) 0 0 0 nil nil)
schCreateWireLabel(cv nil '(19.062 42.750) "VIOH" "lowerRight" "R90" "stick" 0.0625 nil)
schCreateWire(cv "route" "full" '((19.000 44.000) (19.000 44.750)) 0 0 0 nil nil)
schCreateWireLabel(cv nil '(19.000 44.250) "GIOH" "lowerLeft" "R90" "stick" 0.0625 nil)
schCreatePin(cv nil "GIOH" "inputOutput" nil '(19.000 44.750) "R270")
pvdd1dgz_v_gMaster = dbOpenCellView("tphn28hpcpgv18" "PVDD1DGZ_V_G" "symbol")
dbCreateInst(cv pvdd1dgz_v_gMaster "VIOL_top4" '(18.0 44.0) "R180")
schCreateWire(cv "route" "full" '((17.625 43.000) (17.625 42.250)) 0 0 0 nil nil)
schCreateWireLabel(cv nil '(17.625 42.750) "POC" "lowerRight" "R90" "stick" 0.0625 nil)
schCreateWire(cv "route" "full" '((17.000 44.000) (17.000 44.750)) 0 0 0 nil nil)
schCreateWireLabel(cv nil '(17.000 44.250) "VIOL" "lowerLeft" "R90" "stick" 0.0625 nil)
schCreatePin(cv nil "VIOL" "inputOutput" nil '(17.000 44.750) "R270")
schCreateWire(cv "route" "full" '((17.250 43.000) (17.250 42.250)) 0 0 0 nil nil)
schCreateWireLabel(cv nil '(17.250 42.750) "GIOL" "lowerRight" "R90" "stick" 0.0625 nil)
schCreateWire(cv "route" "full" '((17.062 43.000) (17.062 42.250)) 0 0 0 nil nil)
schCreateWireLabel(cv nil '(17.062 42.750) "VIOH" "lowerRight" "R90" "stick" 0.0625 nil)
schCreateWire(cv "route" "full" '((16.688 43.000) (16.688 42.250)) 0 0 0 nil nil)
schCreateWireLabel(cv nil '(16.688 42.750) "GIOH" "lowerRight" "R90" "stick" 0.0625 nil)
pvss1dgz_v_gMaster = dbOpenCellView("tphn28hpcpgv18" "PVSS1DGZ_V_G" "symbol")
dbCreateInst(cv pvss1dgz_v_gMaster "GIOL_top5" '(16.0 44.0) "R180")
schCreateWire(cv "route" "full" '((15.625 43.000) (15.625 42.250)) 0 0 0 nil nil)
schCreateWireLabel(cv nil '(15.625 42.750) "POC" "lowerRight" "R90" "stick" 0.0625 nil)
schCreateWire(cv "route" "full" '((15.438 43.000) (15.438 42.250)) 0 0 0 nil nil)
schCreateWireLabel(cv nil '(15.438 42.750) "VIOL" "lowerRight" "R90" "stick" 0.0625 nil)
schCreateWire(cv "route" "full" '((15.000 44.000) (15.000 44.750)) 0 0 0 nil nil)
schCreateWireLabel(cv nil '(15.000 44.250) "GIOL" "lowerLeft" "R90" "stick" 0.0625 nil)
schCreatePin(cv nil "GIOL" "inputOutput" nil '(15.000 44.750) "R270")
schCreateWire(cv "route" "full" '((15.062 43.000) (15.062 42.250)) 0 0 0 nil nil)
schCreateWireLabel(cv nil '(15.062 42.750) "VIOH" "lowerRight" "R90" "stick" 0.0625 nil)
schCreateWire(cv "route" "full" '((14.688 43.000) (14.688 42.250)) 0 0 0 nil nil)
schCreateWireLabel(cv nil '(14.688 42.750) "GIOH" "lowerRight" "R90" "stick" 0.0625 nil)
dbCreateInst(cv pdb3ac_v_gMaster "IBREF_top6" '(12.8125 44.0) "R180")
schCreateWire(cv "route" "full" '((13.001 44.000) (13.001 44.750)) 0 0 0 nil nil)
schCreateWireLabel(cv nil '(13.001 44.250) "IBREF" "lowerLeft" "R90" "stick" 0.0625 nil)
schCreatePin(cv nil "IBREF" "inputOutput" nil '(13.001 44.750) "R270")
schCreateWire(cv "route" "full" '((13.062 43.125) (13.062 42.375)) 0 0 0 nil nil)
schCreateWireLabel(cv nil '(13.062 42.875) "GNDCMP" "lowerRight" "R90" "stick" 0.0625 nil)
schCreateWire(cv "route" "full" '((12.688 43.125) (12.688 42.375)) 0 0 0 nil nil)
schCreateWireLabel(cv nil '(12.688 42.875) "GIOL" "lowerRight" "R90" "stick" 0.0625 nil)
schCreateWire(cv "route" "full" '((13.438 43.125) (13.438 42.375)) 0 0 0 nil nil)
schCreateWireLabel(cv nil '(13.438 42.875) "VDDCMP" "lowerRight" "R90" "stick" 0.0625 nil)
dbCreateInst(cv pdb3ac_v_gMaster "VREFH_0_top7" '(10.8125 44.0) "R180")
schCreateWire(cv "route" "full" '((11.001 44.000) (11.001 44.750)) 0 0 0 nil nil)
schCreateWireLabel(cv nil '(11.001 44.250) "VREFH<0>" "lowerLeft" "R90" "stick" 0.0625 nil)
schCreatePin(cv nil "VREFH<0>" "inputOutput" nil '(11.001 44.750) "R270")
schCreateWire(cv "route" "full" '((11.062 43.125) (11.062 42.375)) 0 0 0 nil nil)
schCreateWireLabel(cv nil '(11.062 42.875) "GNDCMP" "lowerRight" "R90" "stick" 0.0625 nil)
schCreateWire(cv "route" "full" '((10.688 43.125) (10.688 42.375)) 0 0 0 nil nil)
schCreateWireLabel(cv nil '(10.688 42.875) "GIOL" "lowerRight" "R90" "stick" 0.0625 nil)
schCreateWire(cv "route" "full" '((11.438 43.125) (11.438 42.375)) 0 0 0 nil nil)
schCreateWireLabel(cv nil '(11.438 42.875) "VDDCMP" "lowerRight" "R90" "stick" 0.0625 nil)
dbCreateInst(cv pdb3ac_v_gMaster "VREFH_0_top8" '(8.8125 44.0) "R180")
schCreateWire(cv "route" "full" '((9.001 44.000) (9.001 44.750)) 0 0 0 nil nil)
schCreateWireLabel(cv nil '(9.001 44.250) "VREFH<0>" "lowerLeft" "R90" "stick" 0.0625 nil)
schCreatePin(cv nil "VREFH<0>" "inputOutput" nil '(9.001 44.750) "R270")
schCreateWire(cv "route" "full" '((9.062 43.125) (9.062 42.375)) 0 0 0 nil nil)
schCreateWireLabel(cv nil '(9.062 42.875) "GNDCMP" "lowerRight" "R90" "stick" 0.0625 nil)
schCreateWire(cv "route" "full" '((8.688 43.125) (8.688 42.375)) 0 0 0 nil nil)
schCreateWireLabel(cv nil '(8.688 42.875) "GIOL" "lowerRight" "R90" "stick" 0.0625 nil)
schCreateWire(cv "route" "full" '((9.438 43.125) (9.438 42.375)) 0 0 0 nil nil)
schCreateWireLabel(cv nil '(9.438 42.875) "VDDCMP" "lowerRight" "R90" "stick" 0.0625 nil)
dbCreateInst(cv pdb3ac_v_gMaster "VREFN_0_top9" '(6.8125 44.0) "R180")
schCreateWire(cv "route" "full" '((7.000 44.000) (7.000 44.750)) 0 0 0 nil nil)
schCreateWireLabel(cv nil '(7.000 44.250) "VREFN<0>" "lowerLeft" "R90" "stick" 0.0625 nil)
schCreatePin(cv nil "VREFN<0>" "inputOutput" nil '(7.000 44.750) "R270")
schCreateWire(cv "route" "full" '((7.062 43.125) (7.062 42.375)) 0 0 0 nil nil)
schCreateWireLabel(cv nil '(7.062 42.875) "GNDCMP" "lowerRight" "R90" "stick" 0.0625 nil)
schCreateWire(cv "route" "full" '((6.688 43.125) (6.688 42.375)) 0 0 0 nil nil)
schCreateWireLabel(cv nil '(6.688 42.875) "GIOL" "lowerRight" "R90" "stick" 0.0625 nil)
schCreateWire(cv "route" "full" '((7.438 43.125) (7.438 42.375)) 0 0 0 nil nil)
schCreateWireLabel(cv nil '(7.438 42.875) "VDDCMP" "lowerRight" "R90" "stick" 0.0625 nil)
dbCreateInst(cv pdb3ac_v_gMaster "VREFN_0_top10" '(4.8125 44.0) "R180")
schCreateWire(cv "route" "full" '((5.000 44.000) (5.000 44.750)) 0 0 0 nil nil)
schCreateWireLabel(cv nil '(5.000 44.250) "VREFN<0>" "lowerLeft" "R90" "stick" 0.0625 nil)
schCreatePin(cv nil "VREFN<0>" "inputOutput" nil '(5.000 44.750) "R270")
schCreateWire(cv "route" "full" '((5.062 43.125) (5.062 42.375)) 0 0 0 nil nil)
schCreateWireLabel(cv nil '(5.062 42.875) "GNDCMP" "lowerRight" "R90" "stick" 0.0625 nil)
schCreateWire(cv "route" "full" '((4.688 43.125) (4.688 42.375)) 0 0 0 nil nil)
schCreateWireLabel(cv nil '(4.688 42.875) "GIOL" "lowerRight" "R90" "stick" 0.0625 nil)
schCreateWire(cv "route" "full" '((5.438 43.125) (5.438 42.375)) 0 0 0 nil nil)
schCreateWireLabel(cv nil '(5.438 42.875) "VDDCMP" "lowerRight" "R90" "stick" 0.0625 nil)
dbCreateInst(cv pdb3ac_v_gMaster "VREFDES_top11" '(2.8125 44.0) "R180")
schCreateWire(cv "route" "full" '((3.001 44.000) (3.001 44.750)) 0 0 0 nil nil)
schCreateWireLabel(cv nil '(3.001 44.250) "VREFDES" "lowerLeft" "R90" "stick" 0.0625 nil)
schCreatePin(cv nil "VREFDES" "inputOutput" nil '(3.001 44.750) "R270")
schCreateWire(cv "route" "full" '((3.062 43.125) (3.062 42.375)) 0 0 0 nil nil)
schCreateWireLabel(cv nil '(3.062 42.875) "GNDCMP" "lowerRight" "R90" "stick" 0.0625 nil)
schCreateWire(cv "route" "full" '((2.688 43.125) (2.688 42.375)) 0 0 0 nil nil)
schCreateWireLabel(cv nil '(2.688 42.875) "GIOL" "lowerRight" "R90" "stick" 0.0625 nil)
schCreateWire(cv "route" "full" '((3.438 43.125) (3.438 42.375)) 0 0 0 nil nil)
schCreateWireLabel(cv nil '(3.438 42.875) "VDDCMP" "lowerRight" "R90" "stick" 0.0625 nil)
schCheck(cv)
dbSave(cv)
t
