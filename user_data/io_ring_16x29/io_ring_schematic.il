cv = geGetWindowCellView()
pvdd3ac_h_gMaster = dbOpenCellView("tphn28hpcpgv18" "PVDD3AC_H_G" "symbol")
dbCreateInst(cv pvdd3ac_h_gMaster "VDDCAL_left0" '(0 32.8125) "R270")
schCreateWire(cv "route" "full" '((0.875 33.438) (1.625 33.438)) 0 0 0 nil nil)
schCreateWireLabel(cv nil '(1.125 33.438) "VDDCAL_CORE" "lowerLeft" "R0" "stick" 0.0625 nil)
schCreatePin(cv nil "VDDCAL_CORE" "inputOutput" nil '(1.625 33.438) "R180")
schCreateWire(cv "route" "full" '((0.875 33.062) (1.625 33.062)) 0 0 0 nil nil)
schCreateWireLabel(cv nil '(1.125 33.062) "VSSCAL" "lowerLeft" "R0" "stick" 0.0625 nil)
schCreateWire(cv "route" "full" '((0.875 32.688) (1.625 32.688)) 0 0 0 nil nil)
schCreateWireLabel(cv nil '(1.125 32.688) "GIOL" "lowerLeft" "R0" "stick" 0.0625 nil)
schCreateWire(cv "route" "full" '((0.000 33.001) (-0.750 33.001)) 0 0 0 nil nil)
schCreateWireLabel(cv nil '(-0.250 33.001) "VDDCAL" "lowerRight" "R0" "stick" 0.0625 nil)
schCreatePin(cv nil "VDDCAL" "inputOutput" nil '(-0.750 33.001) "R0")
pvss3ac_h_gMaster = dbOpenCellView("tphn28hpcpgv18" "PVSS3AC_H_G" "symbol")
dbCreateInst(cv pvss3ac_h_gMaster "VSSCAL_left1" '(0 30.8125) "R270")
schCreateWire(cv "route" "full" '((0.000 31.000) (-0.750 31.000)) 0 0 0 nil nil)
schCreateWireLabel(cv nil '(-0.250 31.000) "VSSCAL" "lowerRight" "R0" "stick" 0.0625 nil)
schCreatePin(cv nil "VSSCAL" "inputOutput" nil '(-0.750 31.000) "R0")
schCreateWire(cv "route" "full" '((0.875 30.688) (1.625 30.688)) 0 0 0 nil nil)
schCreateWireLabel(cv nil '(1.125 30.688) "GIOL" "lowerLeft" "R0" "stick" 0.0625 nil)
schCreateWire(cv "route" "full" '((0.875 31.438) (1.625 31.438)) 0 0 0 nil nil)
schCreateWireLabel(cv nil '(1.125 31.438) "VSSCAL_CORE" "lowerLeft" "R0" "stick" 0.0625 nil)
schCreatePin(cv nil "VSSCAL_CORE" "inputOutput" nil '(1.625 31.438) "R180")
schCreateWire(cv "route" "full" '((0.875 31.062) (1.625 31.062)) 0 0 0 nil nil)
schCreateWireLabel(cv nil '(1.125 31.062) "VDDCAL" "lowerLeft" "R0" "stick" 0.0625 nil)
pvdd1ac_h_gMaster = dbOpenCellView("tphn28hpcpgv18" "PVDD1AC_H_G" "symbol")
dbCreateInst(cv pvdd1ac_h_gMaster "CVDD_left2" '(0 28.8125) "R270")
schCreateWire(cv "route" "full" '((0.875 29.062) (1.625 29.062)) 0 0 0 nil nil)
schCreateWireLabel(cv nil '(1.125 29.062) "VSSCAL" "lowerLeft" "R0" "stick" 0.0625 nil)
schCreateWire(cv "route" "full" '((0.875 28.688) (1.625 28.688)) 0 0 0 nil nil)
schCreateWireLabel(cv nil '(1.125 28.688) "GIOL" "lowerLeft" "R0" "stick" 0.0625 nil)
schCreateWire(cv "route" "full" '((0.000 29.000) (-0.750 29.000)) 0 0 0 nil nil)
schCreateWireLabel(cv nil '(-0.250 29.000) "CVDD" "lowerRight" "R0" "stick" 0.0625 nil)
schCreatePin(cv nil "CVDD" "inputOutput" nil '(-0.750 29.000) "R0")
schCreateWire(cv "route" "full" '((0.875 29.438) (1.625 29.438)) 0 0 0 nil nil)
schCreateWireLabel(cv nil '(1.125 29.438) "VDDCAL" "lowerLeft" "R0" "stick" 0.0625 nil)
pdb3ac_h_gMaster = dbOpenCellView("tphn28hpcpgv18" "PDB3AC_H_G" "symbol")
dbCreateInst(cv pdb3ac_h_gMaster "CLKP_left3" '(0 26.8125) "R270")
schCreateWire(cv "route" "full" '((0.000 27.000) (-0.750 27.000)) 0 0 0 nil nil)
schCreateWireLabel(cv nil '(-0.250 27.000) "CLKP" "lowerRight" "R0" "stick" 0.0625 nil)
schCreatePin(cv nil "CLKP" "inputOutput" nil '(-0.750 27.000) "R0")
schCreateWire(cv "route" "full" '((0.875 27.062) (1.625 27.062)) 0 0 0 nil nil)
schCreateWireLabel(cv nil '(1.125 27.062) "VSSCAL" "lowerLeft" "R0" "stick" 0.0625 nil)
schCreateWire(cv "route" "full" '((0.875 26.688) (1.625 26.688)) 0 0 0 nil nil)
schCreateWireLabel(cv nil '(1.125 26.688) "GIOL" "lowerLeft" "R0" "stick" 0.0625 nil)
schCreateWire(cv "route" "full" '((0.875 27.438) (1.625 27.438)) 0 0 0 nil nil)
schCreateWireLabel(cv nil '(1.125 27.438) "VDDCAL" "lowerLeft" "R0" "stick" 0.0625 nil)
dbCreateInst(cv pdb3ac_h_gMaster "CLKN_left4" '(0 24.8125) "R270")
schCreateWire(cv "route" "full" '((0.000 25.000) (-0.750 25.000)) 0 0 0 nil nil)
schCreateWireLabel(cv nil '(-0.250 25.000) "CLKN" "lowerRight" "R0" "stick" 0.0625 nil)
schCreatePin(cv nil "CLKN" "inputOutput" nil '(-0.750 25.000) "R0")
schCreateWire(cv "route" "full" '((0.875 25.062) (1.625 25.062)) 0 0 0 nil nil)
schCreateWireLabel(cv nil '(1.125 25.062) "VSSCAL" "lowerLeft" "R0" "stick" 0.0625 nil)
schCreateWire(cv "route" "full" '((0.875 24.688) (1.625 24.688)) 0 0 0 nil nil)
schCreateWireLabel(cv nil '(1.125 24.688) "GIOL" "lowerLeft" "R0" "stick" 0.0625 nil)
schCreateWire(cv "route" "full" '((0.875 25.438) (1.625 25.438)) 0 0 0 nil nil)
schCreateWireLabel(cv nil '(1.125 25.438) "VDDCAL" "lowerLeft" "R0" "stick" 0.0625 nil)
pvss1ac_h_gMaster = dbOpenCellView("tphn28hpcpgv18" "PVSS1AC_H_G" "symbol")
dbCreateInst(cv pvss1ac_h_gMaster "CVSS_left5" '(0 22.8125) "R270")
schCreateWire(cv "route" "full" '((0.000 23.000) (-0.750 23.000)) 0 0 0 nil nil)
schCreateWireLabel(cv nil '(-0.250 23.000) "CVSS" "lowerRight" "R0" "stick" 0.0625 nil)
schCreatePin(cv nil "CVSS" "inputOutput" nil '(-0.750 23.000) "R0")
schCreateWire(cv "route" "full" '((0.875 23.062) (1.625 23.062)) 0 0 0 nil nil)
schCreateWireLabel(cv nil '(1.125 23.062) "VSSCAL" "lowerLeft" "R0" "stick" 0.0625 nil)
schCreateWire(cv "route" "full" '((0.875 22.688) (1.625 22.688)) 0 0 0 nil nil)
schCreateWireLabel(cv nil '(1.125 22.688) "GIOL" "lowerLeft" "R0" "stick" 0.0625 nil)
schCreateWire(cv "route" "full" '((0.875 23.438) (1.625 23.438)) 0 0 0 nil nil)
schCreateWireLabel(cv nil '(1.125 23.438) "VDDCAL" "lowerLeft" "R0" "stick" 0.0625 nil)
dbCreateInst(cv pvss1ac_h_gMaster "AVSS2_left6" '(0 20.8125) "R270")
schCreateWire(cv "route" "full" '((0.000 21.000) (-0.750 21.000)) 0 0 0 nil nil)
schCreateWireLabel(cv nil '(-0.250 21.000) "AVSS2" "lowerRight" "R0" "stick" 0.0625 nil)
schCreatePin(cv nil "AVSS2" "inputOutput" nil '(-0.750 21.000) "R0")
schCreateWire(cv "route" "full" '((0.875 21.062) (1.625 21.062)) 0 0 0 nil nil)
schCreateWireLabel(cv nil '(1.125 21.062) "VSSCAL" "lowerLeft" "R0" "stick" 0.0625 nil)
schCreateWire(cv "route" "full" '((0.875 20.688) (1.625 20.688)) 0 0 0 nil nil)
schCreateWireLabel(cv nil '(1.125 20.688) "GIOL" "lowerLeft" "R0" "stick" 0.0625 nil)
schCreateWire(cv "route" "full" '((0.875 21.438) (1.625 21.438)) 0 0 0 nil nil)
schCreateWireLabel(cv nil '(1.125 21.438) "VDDCAL" "lowerLeft" "R0" "stick" 0.0625 nil)
dbCreateInst(cv pvss1ac_h_gMaster "AVSS2_left7" '(0 18.8125) "R270")
schCreateWire(cv "route" "full" '((0.000 19.000) (-0.750 19.000)) 0 0 0 nil nil)
schCreateWireLabel(cv nil '(-0.250 19.000) "AVSS2" "lowerRight" "R0" "stick" 0.0625 nil)
schCreatePin(cv nil "AVSS2" "inputOutput" nil '(-0.750 19.000) "R0")
schCreateWire(cv "route" "full" '((0.875 19.062) (1.625 19.062)) 0 0 0 nil nil)
schCreateWireLabel(cv nil '(1.125 19.062) "VSSCAL" "lowerLeft" "R0" "stick" 0.0625 nil)
schCreateWire(cv "route" "full" '((0.875 18.688) (1.625 18.688)) 0 0 0 nil nil)
schCreateWireLabel(cv nil '(1.125 18.688) "GIOL" "lowerLeft" "R0" "stick" 0.0625 nil)
schCreateWire(cv "route" "full" '((0.875 19.438) (1.625 19.438)) 0 0 0 nil nil)
schCreateWireLabel(cv nil '(1.125 19.438) "VDDCAL" "lowerLeft" "R0" "stick" 0.0625 nil)
dbCreateInst(cv pvdd1ac_h_gMaster "AVDDH2_left8" '(0 16.8125) "R270")
schCreateWire(cv "route" "full" '((0.875 17.062) (1.625 17.062)) 0 0 0 nil nil)
schCreateWireLabel(cv nil '(1.125 17.062) "VSSCAL" "lowerLeft" "R0" "stick" 0.0625 nil)
schCreateWire(cv "route" "full" '((0.875 16.688) (1.625 16.688)) 0 0 0 nil nil)
schCreateWireLabel(cv nil '(1.125 16.688) "GIOL" "lowerLeft" "R0" "stick" 0.0625 nil)
schCreateWire(cv "route" "full" '((0.000 17.000) (-0.750 17.000)) 0 0 0 nil nil)
schCreateWireLabel(cv nil '(-0.250 17.000) "AVDDH2" "lowerRight" "R0" "stick" 0.0625 nil)
schCreatePin(cv nil "AVDDH2" "inputOutput" nil '(-0.750 17.000) "R0")
schCreateWire(cv "route" "full" '((0.875 17.438) (1.625 17.438)) 0 0 0 nil nil)
schCreateWireLabel(cv nil '(1.125 17.438) "VDDCAL" "lowerLeft" "R0" "stick" 0.0625 nil)
dbCreateInst(cv pvdd1ac_h_gMaster "AVDDH2_left9" '(0 14.8125) "R270")
schCreateWire(cv "route" "full" '((0.875 15.062) (1.625 15.062)) 0 0 0 nil nil)
schCreateWireLabel(cv nil '(1.125 15.062) "VSSCAL" "lowerLeft" "R0" "stick" 0.0625 nil)
schCreateWire(cv "route" "full" '((0.875 14.688) (1.625 14.688)) 0 0 0 nil nil)
schCreateWireLabel(cv nil '(1.125 14.688) "GIOL" "lowerLeft" "R0" "stick" 0.0625 nil)
schCreateWire(cv "route" "full" '((0.000 15.001) (-0.750 15.001)) 0 0 0 nil nil)
schCreateWireLabel(cv nil '(-0.250 15.001) "AVDDH2" "lowerRight" "R0" "stick" 0.0625 nil)
schCreatePin(cv nil "AVDDH2" "inputOutput" nil '(-0.750 15.001) "R0")
schCreateWire(cv "route" "full" '((0.875 15.438) (1.625 15.438)) 0 0 0 nil nil)
schCreateWireLabel(cv nil '(1.125 15.438) "VDDCAL" "lowerLeft" "R0" "stick" 0.0625 nil)
dbCreateInst(cv pdb3ac_h_gMaster "IBOTA2_left10" '(0 12.8125) "R270")
schCreateWire(cv "route" "full" '((0.000 13.001) (-0.750 13.001)) 0 0 0 nil nil)
schCreateWireLabel(cv nil '(-0.250 13.001) "IBOTA2" "lowerRight" "R0" "stick" 0.0625 nil)
schCreatePin(cv nil "IBOTA2" "inputOutput" nil '(-0.750 13.001) "R0")
schCreateWire(cv "route" "full" '((0.875 13.062) (1.625 13.062)) 0 0 0 nil nil)
schCreateWireLabel(cv nil '(1.125 13.062) "VSSCAL" "lowerLeft" "R0" "stick" 0.0625 nil)
schCreateWire(cv "route" "full" '((0.875 12.688) (1.625 12.688)) 0 0 0 nil nil)
schCreateWireLabel(cv nil '(1.125 12.688) "GIOL" "lowerLeft" "R0" "stick" 0.0625 nil)
schCreateWire(cv "route" "full" '((0.875 13.438) (1.625 13.438)) 0 0 0 nil nil)
schCreateWireLabel(cv nil '(1.125 13.438) "VDDCAL" "lowerLeft" "R0" "stick" 0.0625 nil)
dbCreateInst(cv pdb3ac_h_gMaster "IBF_left11" '(0 10.8125) "R270")
schCreateWire(cv "route" "full" '((0.000 11.001) (-0.750 11.001)) 0 0 0 nil nil)
schCreateWireLabel(cv nil '(-0.250 11.001) "IBF" "lowerRight" "R0" "stick" 0.0625 nil)
schCreatePin(cv nil "IBF" "inputOutput" nil '(-0.750 11.001) "R0")
schCreateWire(cv "route" "full" '((0.875 11.062) (1.625 11.062)) 0 0 0 nil nil)
schCreateWireLabel(cv nil '(1.125 11.062) "VSSCAL" "lowerLeft" "R0" "stick" 0.0625 nil)
schCreateWire(cv "route" "full" '((0.875 10.688) (1.625 10.688)) 0 0 0 nil nil)
schCreateWireLabel(cv nil '(1.125 10.688) "GIOL" "lowerLeft" "R0" "stick" 0.0625 nil)
schCreateWire(cv "route" "full" '((0.875 11.438) (1.625 11.438)) 0 0 0 nil nil)
schCreateWireLabel(cv nil '(1.125 11.438) "VDDCAL" "lowerLeft" "R0" "stick" 0.0625 nil)
dbCreateInst(cv pdb3ac_h_gMaster "VREFN2_left12" '(0 8.8125) "R270")
schCreateWire(cv "route" "full" '((0.000 9.001) (-0.750 9.001)) 0 0 0 nil nil)
schCreateWireLabel(cv nil '(-0.250 9.001) "VREFN2" "lowerRight" "R0" "stick" 0.0625 nil)
schCreatePin(cv nil "VREFN2" "inputOutput" nil '(-0.750 9.001) "R0")
schCreateWire(cv "route" "full" '((0.875 9.062) (1.625 9.062)) 0 0 0 nil nil)
schCreateWireLabel(cv nil '(1.125 9.062) "VSSCAL" "lowerLeft" "R0" "stick" 0.0625 nil)
schCreateWire(cv "route" "full" '((0.875 8.688) (1.625 8.688)) 0 0 0 nil nil)
schCreateWireLabel(cv nil '(1.125 8.688) "GIOL" "lowerLeft" "R0" "stick" 0.0625 nil)
schCreateWire(cv "route" "full" '((0.875 9.438) (1.625 9.438)) 0 0 0 nil nil)
schCreateWireLabel(cv nil '(1.125 9.438) "VDDCAL" "lowerLeft" "R0" "stick" 0.0625 nil)
dbCreateInst(cv pdb3ac_h_gMaster "VREFP2_left13" '(0 6.8125) "R270")
schCreateWire(cv "route" "full" '((0.000 7.000) (-0.750 7.000)) 0 0 0 nil nil)
schCreateWireLabel(cv nil '(-0.250 7.000) "VREFP2" "lowerRight" "R0" "stick" 0.0625 nil)
schCreatePin(cv nil "VREFP2" "inputOutput" nil '(-0.750 7.000) "R0")
schCreateWire(cv "route" "full" '((0.875 7.062) (1.625 7.062)) 0 0 0 nil nil)
schCreateWireLabel(cv nil '(1.125 7.062) "VSSCAL" "lowerLeft" "R0" "stick" 0.0625 nil)
schCreateWire(cv "route" "full" '((0.875 6.688) (1.625 6.688)) 0 0 0 nil nil)
schCreateWireLabel(cv nil '(1.125 6.688) "GIOL" "lowerLeft" "R0" "stick" 0.0625 nil)
schCreateWire(cv "route" "full" '((0.875 7.438) (1.625 7.438)) 0 0 0 nil nil)
schCreateWireLabel(cv nil '(1.125 7.438) "VDDCAL" "lowerLeft" "R0" "stick" 0.0625 nil)
dbCreateInst(cv pdb3ac_h_gMaster "VREFPF2_left14" '(0 4.8125) "R270")
schCreateWire(cv "route" "full" '((0.000 5.000) (-0.750 5.000)) 0 0 0 nil nil)
schCreateWireLabel(cv nil '(-0.250 5.000) "VREFPF2" "lowerRight" "R0" "stick" 0.0625 nil)
schCreatePin(cv nil "VREFPF2" "inputOutput" nil '(-0.750 5.000) "R0")
schCreateWire(cv "route" "full" '((0.875 5.062) (1.625 5.062)) 0 0 0 nil nil)
schCreateWireLabel(cv nil '(1.125 5.062) "VSSCAL" "lowerLeft" "R0" "stick" 0.0625 nil)
schCreateWire(cv "route" "full" '((0.875 4.688) (1.625 4.688)) 0 0 0 nil nil)
schCreateWireLabel(cv nil '(1.125 4.688) "GIOL" "lowerLeft" "R0" "stick" 0.0625 nil)
schCreateWire(cv "route" "full" '((0.875 5.438) (1.625 5.438)) 0 0 0 nil nil)
schCreateWireLabel(cv nil '(1.125 5.438) "VDDCAL" "lowerLeft" "R0" "stick" 0.0625 nil)
dbCreateInst(cv pdb3ac_h_gMaster "VREFNF2_left15" '(0 2.8125) "R270")
schCreateWire(cv "route" "full" '((0.000 3.001) (-0.750 3.001)) 0 0 0 nil nil)
schCreateWireLabel(cv nil '(-0.250 3.001) "VREFNF2" "lowerRight" "R0" "stick" 0.0625 nil)
schCreatePin(cv nil "VREFNF2" "inputOutput" nil '(-0.750 3.001) "R0")
schCreateWire(cv "route" "full" '((0.875 3.062) (1.625 3.062)) 0 0 0 nil nil)
schCreateWireLabel(cv nil '(1.125 3.062) "VSSCAL" "lowerLeft" "R0" "stick" 0.0625 nil)
schCreateWire(cv "route" "full" '((0.875 2.688) (1.625 2.688)) 0 0 0 nil nil)
schCreateWireLabel(cv nil '(1.125 2.688) "GIOL" "lowerLeft" "R0" "stick" 0.0625 nil)
schCreateWire(cv "route" "full" '((0.875 3.438) (1.625 3.438)) 0 0 0 nil nil)
schCreateWireLabel(cv nil '(1.125 3.438) "VDDCAL" "lowerLeft" "R0" "stick" 0.0625 nil)
pvss1ac_v_gMaster = dbOpenCellView("tphn28hpcpgv18" "PVSS1AC_V_G" "symbol")
dbCreateInst(cv pvss1ac_v_gMaster "CVSS_bottom0" '(3.1875 0) "R0")
schCreateWire(cv "route" "full" '((2.999 0.000) (2.999 -0.750)) 0 0 0 nil nil)
schCreateWireLabel(cv nil '(2.999 -0.250) "CVSS" "lowerRight" "R90" "stick" 0.0625 nil)
schCreatePin(cv nil "CVSS" "inputOutput" nil '(2.999 -0.750) "R90")
schCreateWire(cv "route" "full" '((2.938 0.875) (2.938 1.625)) 0 0 0 nil nil)
schCreateWireLabel(cv nil '(2.938 1.125) "VSSCAL" "lowerLeft" "R90" "stick" 0.0625 nil)
schCreateWire(cv "route" "full" '((3.312 0.875) (3.312 1.625)) 0 0 0 nil nil)
schCreateWireLabel(cv nil '(3.312 1.125) "GIOL" "lowerLeft" "R90" "stick" 0.0625 nil)
schCreateWire(cv "route" "full" '((2.562 0.875) (2.562 1.625)) 0 0 0 nil nil)
schCreateWireLabel(cv nil '(2.562 1.125) "VDDCAL" "lowerLeft" "R90" "stick" 0.0625 nil)
pvdd1ac_v_gMaster = dbOpenCellView("tphn28hpcpgv18" "PVDD1AC_V_G" "symbol")
dbCreateInst(cv pvdd1ac_v_gMaster "CVDD_bottom1" '(5.1875 0) "R0")
schCreateWire(cv "route" "full" '((4.938 0.875) (4.938 1.625)) 0 0 0 nil nil)
schCreateWireLabel(cv nil '(4.938 1.125) "VSSCAL" "lowerLeft" "R90" "stick" 0.0625 nil)
schCreateWire(cv "route" "full" '((5.312 0.875) (5.312 1.625)) 0 0 0 nil nil)
schCreateWireLabel(cv nil '(5.312 1.125) "GIOL" "lowerLeft" "R90" "stick" 0.0625 nil)
schCreateWire(cv "route" "full" '((5.000 0.000) (5.000 -0.750)) 0 0 0 nil nil)
schCreateWireLabel(cv nil '(5.000 -0.250) "CVDD" "lowerRight" "R90" "stick" 0.0625 nil)
schCreatePin(cv nil "CVDD" "inputOutput" nil '(5.000 -0.750) "R90")
schCreateWire(cv "route" "full" '((4.562 0.875) (4.562 1.625)) 0 0 0 nil nil)
schCreateWireLabel(cv nil '(4.562 1.125) "VDDCAL" "lowerLeft" "R90" "stick" 0.0625 nil)
pdb3ac_v_gMaster = dbOpenCellView("tphn28hpcpgv18" "PDB3AC_V_G" "symbol")
dbCreateInst(cv pdb3ac_v_gMaster "IBOTA1_bottom2" '(7.1875 0) "R0")
schCreateWire(cv "route" "full" '((7.000 0.000) (7.000 -0.750)) 0 0 0 nil nil)
schCreateWireLabel(cv nil '(7.000 -0.250) "IBOTA1" "lowerRight" "R90" "stick" 0.0625 nil)
schCreatePin(cv nil "IBOTA1" "inputOutput" nil '(7.000 -0.750) "R90")
schCreateWire(cv "route" "full" '((6.938 0.875) (6.938 1.625)) 0 0 0 nil nil)
schCreateWireLabel(cv nil '(6.938 1.125) "VSSCAL" "lowerLeft" "R90" "stick" 0.0625 nil)
schCreateWire(cv "route" "full" '((7.312 0.875) (7.312 1.625)) 0 0 0 nil nil)
schCreateWireLabel(cv nil '(7.312 1.125) "GIOL" "lowerLeft" "R90" "stick" 0.0625 nil)
schCreateWire(cv "route" "full" '((6.562 0.875) (6.562 1.625)) 0 0 0 nil nil)
schCreateWireLabel(cv nil '(6.562 1.125) "VDDCAL" "lowerLeft" "R90" "stick" 0.0625 nil)
dbCreateInst(cv pvdd1ac_v_gMaster "AVDDH1_bottom3" '(9.1875 0) "R0")
schCreateWire(cv "route" "full" '((8.938 0.875) (8.938 1.625)) 0 0 0 nil nil)
schCreateWireLabel(cv nil '(8.938 1.125) "VSSCAL" "lowerLeft" "R90" "stick" 0.0625 nil)
schCreateWire(cv "route" "full" '((9.312 0.875) (9.312 1.625)) 0 0 0 nil nil)
schCreateWireLabel(cv nil '(9.312 1.125) "GIOL" "lowerLeft" "R90" "stick" 0.0625 nil)
schCreateWire(cv "route" "full" '((8.999 0.000) (8.999 -0.750)) 0 0 0 nil nil)
schCreateWireLabel(cv nil '(8.999 -0.250) "AVDDH1" "lowerRight" "R90" "stick" 0.0625 nil)
schCreatePin(cv nil "AVDDH1" "inputOutput" nil '(8.999 -0.750) "R90")
schCreateWire(cv "route" "full" '((8.562 0.875) (8.562 1.625)) 0 0 0 nil nil)
schCreateWireLabel(cv nil '(8.562 1.125) "VDDCAL" "lowerLeft" "R90" "stick" 0.0625 nil)
dbCreateInst(cv pvdd1ac_v_gMaster "AVDDH1_bottom4" '(11.1875 0) "R0")
schCreateWire(cv "route" "full" '((10.938 0.875) (10.938 1.625)) 0 0 0 nil nil)
schCreateWireLabel(cv nil '(10.938 1.125) "VSSCAL" "lowerLeft" "R90" "stick" 0.0625 nil)
schCreateWire(cv "route" "full" '((11.312 0.875) (11.312 1.625)) 0 0 0 nil nil)
schCreateWireLabel(cv nil '(11.312 1.125) "GIOL" "lowerLeft" "R90" "stick" 0.0625 nil)
schCreateWire(cv "route" "full" '((10.999 0.000) (10.999 -0.750)) 0 0 0 nil nil)
schCreateWireLabel(cv nil '(10.999 -0.250) "AVDDH1" "lowerRight" "R90" "stick" 0.0625 nil)
schCreatePin(cv nil "AVDDH1" "inputOutput" nil '(10.999 -0.750) "R90")
schCreateWire(cv "route" "full" '((10.562 0.875) (10.562 1.625)) 0 0 0 nil nil)
schCreateWireLabel(cv nil '(10.562 1.125) "VDDCAL" "lowerLeft" "R90" "stick" 0.0625 nil)
dbCreateInst(cv pvss1ac_v_gMaster "AVSS1_bottom5" '(13.1875 0) "R0")
schCreateWire(cv "route" "full" '((12.999 0.000) (12.999 -0.750)) 0 0 0 nil nil)
schCreateWireLabel(cv nil '(12.999 -0.250) "AVSS1" "lowerRight" "R90" "stick" 0.0625 nil)
schCreatePin(cv nil "AVSS1" "inputOutput" nil '(12.999 -0.750) "R90")
schCreateWire(cv "route" "full" '((12.938 0.875) (12.938 1.625)) 0 0 0 nil nil)
schCreateWireLabel(cv nil '(12.938 1.125) "VSSCAL" "lowerLeft" "R90" "stick" 0.0625 nil)
schCreateWire(cv "route" "full" '((13.312 0.875) (13.312 1.625)) 0 0 0 nil nil)
schCreateWireLabel(cv nil '(13.312 1.125) "GIOL" "lowerLeft" "R90" "stick" 0.0625 nil)
schCreateWire(cv "route" "full" '((12.562 0.875) (12.562 1.625)) 0 0 0 nil nil)
schCreateWireLabel(cv nil '(12.562 1.125) "VDDCAL" "lowerLeft" "R90" "stick" 0.0625 nil)
dbCreateInst(cv pvss1ac_v_gMaster "AVSS1_bottom6" '(15.1875 0) "R0")
schCreateWire(cv "route" "full" '((14.999 0.000) (14.999 -0.750)) 0 0 0 nil nil)
schCreateWireLabel(cv nil '(14.999 -0.250) "AVSS1" "lowerRight" "R90" "stick" 0.0625 nil)
schCreatePin(cv nil "AVSS1" "inputOutput" nil '(14.999 -0.750) "R90")
schCreateWire(cv "route" "full" '((14.938 0.875) (14.938 1.625)) 0 0 0 nil nil)
schCreateWireLabel(cv nil '(14.938 1.125) "VSSCAL" "lowerLeft" "R90" "stick" 0.0625 nil)
schCreateWire(cv "route" "full" '((15.312 0.875) (15.312 1.625)) 0 0 0 nil nil)
schCreateWireLabel(cv nil '(15.312 1.125) "GIOL" "lowerLeft" "R90" "stick" 0.0625 nil)
schCreateWire(cv "route" "full" '((14.562 0.875) (14.562 1.625)) 0 0 0 nil nil)
schCreateWireLabel(cv nil '(14.562 1.125) "VDDCAL" "lowerLeft" "R90" "stick" 0.0625 nil)
dbCreateInst(cv pdb3ac_v_gMaster "VREFN1_bottom7" '(17.1875 0) "R0")
schCreateWire(cv "route" "full" '((17.000 0.000) (17.000 -0.750)) 0 0 0 nil nil)
schCreateWireLabel(cv nil '(17.000 -0.250) "VREFN1" "lowerRight" "R90" "stick" 0.0625 nil)
schCreatePin(cv nil "VREFN1" "inputOutput" nil '(17.000 -0.750) "R90")
schCreateWire(cv "route" "full" '((16.938 0.875) (16.938 1.625)) 0 0 0 nil nil)
schCreateWireLabel(cv nil '(16.938 1.125) "VSSCAL" "lowerLeft" "R90" "stick" 0.0625 nil)
schCreateWire(cv "route" "full" '((17.312 0.875) (17.312 1.625)) 0 0 0 nil nil)
schCreateWireLabel(cv nil '(17.312 1.125) "GIOL" "lowerLeft" "R90" "stick" 0.0625 nil)
schCreateWire(cv "route" "full" '((16.562 0.875) (16.562 1.625)) 0 0 0 nil nil)
schCreateWireLabel(cv nil '(16.562 1.125) "VDDCAL" "lowerLeft" "R90" "stick" 0.0625 nil)
dbCreateInst(cv pdb3ac_v_gMaster "VREFP1_bottom8" '(19.1875 0) "R0")
schCreateWire(cv "route" "full" '((19.000 0.000) (19.000 -0.750)) 0 0 0 nil nil)
schCreateWireLabel(cv nil '(19.000 -0.250) "VREFP1" "lowerRight" "R90" "stick" 0.0625 nil)
schCreatePin(cv nil "VREFP1" "inputOutput" nil '(19.000 -0.750) "R90")
schCreateWire(cv "route" "full" '((18.938 0.875) (18.938 1.625)) 0 0 0 nil nil)
schCreateWireLabel(cv nil '(18.938 1.125) "VSSCAL" "lowerLeft" "R90" "stick" 0.0625 nil)
schCreateWire(cv "route" "full" '((19.312 0.875) (19.312 1.625)) 0 0 0 nil nil)
schCreateWireLabel(cv nil '(19.312 1.125) "GIOL" "lowerLeft" "R90" "stick" 0.0625 nil)
schCreateWire(cv "route" "full" '((18.562 0.875) (18.562 1.625)) 0 0 0 nil nil)
schCreateWireLabel(cv nil '(18.562 1.125) "VDDCAL" "lowerLeft" "R90" "stick" 0.0625 nil)
dbCreateInst(cv pdb3ac_v_gMaster "VREFNF1_bottom9" '(21.1875 0) "R0")
schCreateWire(cv "route" "full" '((21.000 0.000) (21.000 -0.750)) 0 0 0 nil nil)
schCreateWireLabel(cv nil '(21.000 -0.250) "VREFNF1" "lowerRight" "R90" "stick" 0.0625 nil)
schCreatePin(cv nil "VREFNF1" "inputOutput" nil '(21.000 -0.750) "R90")
schCreateWire(cv "route" "full" '((20.938 0.875) (20.938 1.625)) 0 0 0 nil nil)
schCreateWireLabel(cv nil '(20.938 1.125) "VSSCAL" "lowerLeft" "R90" "stick" 0.0625 nil)
schCreateWire(cv "route" "full" '((21.312 0.875) (21.312 1.625)) 0 0 0 nil nil)
schCreateWireLabel(cv nil '(21.312 1.125) "GIOL" "lowerLeft" "R90" "stick" 0.0625 nil)
schCreateWire(cv "route" "full" '((20.562 0.875) (20.562 1.625)) 0 0 0 nil nil)
schCreateWireLabel(cv nil '(20.562 1.125) "VDDCAL" "lowerLeft" "R90" "stick" 0.0625 nil)
dbCreateInst(cv pdb3ac_v_gMaster "VCM_bottom10" '(23.1875 0) "R0")
schCreateWire(cv "route" "full" '((23.000 0.000) (23.000 -0.750)) 0 0 0 nil nil)
schCreateWireLabel(cv nil '(23.000 -0.250) "VCM" "lowerRight" "R90" "stick" 0.0625 nil)
schCreatePin(cv nil "VCM" "inputOutput" nil '(23.000 -0.750) "R90")
schCreateWire(cv "route" "full" '((22.938 0.875) (22.938 1.625)) 0 0 0 nil nil)
schCreateWireLabel(cv nil '(22.938 1.125) "VSSCAL" "lowerLeft" "R90" "stick" 0.0625 nil)
schCreateWire(cv "route" "full" '((23.312 0.875) (23.312 1.625)) 0 0 0 nil nil)
schCreateWireLabel(cv nil '(23.312 1.125) "GIOL" "lowerLeft" "R90" "stick" 0.0625 nil)
schCreateWire(cv "route" "full" '((22.562 0.875) (22.562 1.625)) 0 0 0 nil nil)
schCreateWireLabel(cv nil '(22.562 1.125) "VDDCAL" "lowerLeft" "R90" "stick" 0.0625 nil)
dbCreateInst(cv pdb3ac_v_gMaster "VINN_bottom11" '(25.1875 0) "R0")
schCreateWire(cv "route" "full" '((25.000 0.000) (25.000 -0.750)) 0 0 0 nil nil)
schCreateWireLabel(cv nil '(25.000 -0.250) "VINN" "lowerRight" "R90" "stick" 0.0625 nil)
schCreatePin(cv nil "VINN" "inputOutput" nil '(25.000 -0.750) "R90")
schCreateWire(cv "route" "full" '((24.938 0.875) (24.938 1.625)) 0 0 0 nil nil)
schCreateWireLabel(cv nil '(24.938 1.125) "VSSCAL" "lowerLeft" "R90" "stick" 0.0625 nil)
schCreateWire(cv "route" "full" '((25.312 0.875) (25.312 1.625)) 0 0 0 nil nil)
schCreateWireLabel(cv nil '(25.312 1.125) "GIOL" "lowerLeft" "R90" "stick" 0.0625 nil)
schCreateWire(cv "route" "full" '((24.562 0.875) (24.562 1.625)) 0 0 0 nil nil)
schCreateWireLabel(cv nil '(24.562 1.125) "VDDCAL" "lowerLeft" "R90" "stick" 0.0625 nil)
dbCreateInst(cv pdb3ac_v_gMaster "VINN_bottom12" '(27.1875 0) "R0")
schCreateWire(cv "route" "full" '((27.000 0.000) (27.000 -0.750)) 0 0 0 nil nil)
schCreateWireLabel(cv nil '(27.000 -0.250) "VINN" "lowerRight" "R90" "stick" 0.0625 nil)
schCreatePin(cv nil "VINN" "inputOutput" nil '(27.000 -0.750) "R90")
schCreateWire(cv "route" "full" '((26.938 0.875) (26.938 1.625)) 0 0 0 nil nil)
schCreateWireLabel(cv nil '(26.938 1.125) "VSSCAL" "lowerLeft" "R90" "stick" 0.0625 nil)
schCreateWire(cv "route" "full" '((27.312 0.875) (27.312 1.625)) 0 0 0 nil nil)
schCreateWireLabel(cv nil '(27.312 1.125) "GIOL" "lowerLeft" "R90" "stick" 0.0625 nil)
schCreateWire(cv "route" "full" '((26.562 0.875) (26.562 1.625)) 0 0 0 nil nil)
schCreateWireLabel(cv nil '(26.562 1.125) "VDDCAL" "lowerLeft" "R90" "stick" 0.0625 nil)
dbCreateInst(cv pdb3ac_v_gMaster "VINP_bottom13" '(29.1875 0) "R0")
schCreateWire(cv "route" "full" '((29.000 0.000) (29.000 -0.750)) 0 0 0 nil nil)
schCreateWireLabel(cv nil '(29.000 -0.250) "VINP" "lowerRight" "R90" "stick" 0.0625 nil)
schCreatePin(cv nil "VINP" "inputOutput" nil '(29.000 -0.750) "R90")
schCreateWire(cv "route" "full" '((28.938 0.875) (28.938 1.625)) 0 0 0 nil nil)
schCreateWireLabel(cv nil '(28.938 1.125) "VSSCAL" "lowerLeft" "R90" "stick" 0.0625 nil)
schCreateWire(cv "route" "full" '((29.312 0.875) (29.312 1.625)) 0 0 0 nil nil)
schCreateWireLabel(cv nil '(29.312 1.125) "GIOL" "lowerLeft" "R90" "stick" 0.0625 nil)
schCreateWire(cv "route" "full" '((28.562 0.875) (28.562 1.625)) 0 0 0 nil nil)
schCreateWireLabel(cv nil '(28.562 1.125) "VDDCAL" "lowerLeft" "R90" "stick" 0.0625 nil)
dbCreateInst(cv pdb3ac_v_gMaster "VINP_bottom14" '(31.1875 0) "R0")
schCreateWire(cv "route" "full" '((31.000 0.000) (31.000 -0.750)) 0 0 0 nil nil)
schCreateWireLabel(cv nil '(31.000 -0.250) "VINP" "lowerRight" "R90" "stick" 0.0625 nil)
schCreatePin(cv nil "VINP" "inputOutput" nil '(31.000 -0.750) "R90")
schCreateWire(cv "route" "full" '((30.938 0.875) (30.938 1.625)) 0 0 0 nil nil)
schCreateWireLabel(cv nil '(30.938 1.125) "VSSCAL" "lowerLeft" "R90" "stick" 0.0625 nil)
schCreateWire(cv "route" "full" '((31.312 0.875) (31.312 1.625)) 0 0 0 nil nil)
schCreateWireLabel(cv nil '(31.312 1.125) "GIOL" "lowerLeft" "R90" "stick" 0.0625 nil)
schCreateWire(cv "route" "full" '((30.562 0.875) (30.562 1.625)) 0 0 0 nil nil)
schCreateWireLabel(cv nil '(30.562 1.125) "VDDCAL" "lowerLeft" "R90" "stick" 0.0625 nil)
dbCreateInst(cv pdb3ac_v_gMaster "VCM_bottom15" '(33.1875 0) "R0")
schCreateWire(cv "route" "full" '((32.999 0.000) (32.999 -0.750)) 0 0 0 nil nil)
schCreateWireLabel(cv nil '(32.999 -0.250) "VCM" "lowerRight" "R90" "stick" 0.0625 nil)
schCreatePin(cv nil "VCM" "inputOutput" nil '(32.999 -0.750) "R90")
schCreateWire(cv "route" "full" '((32.938 0.875) (32.938 1.625)) 0 0 0 nil nil)
schCreateWireLabel(cv nil '(32.938 1.125) "VSSCAL" "lowerLeft" "R90" "stick" 0.0625 nil)
schCreateWire(cv "route" "full" '((33.312 0.875) (33.312 1.625)) 0 0 0 nil nil)
schCreateWireLabel(cv nil '(33.312 1.125) "GIOL" "lowerLeft" "R90" "stick" 0.0625 nil)
schCreateWire(cv "route" "full" '((32.562 0.875) (32.562 1.625)) 0 0 0 nil nil)
schCreateWireLabel(cv nil '(32.562 1.125) "VDDCAL" "lowerLeft" "R90" "stick" 0.0625 nil)
dbCreateInst(cv pdb3ac_v_gMaster "VREFPF1_bottom16" '(35.1875 0) "R0")
schCreateWire(cv "route" "full" '((34.999 0.000) (34.999 -0.750)) 0 0 0 nil nil)
schCreateWireLabel(cv nil '(34.999 -0.250) "VREFPF1" "lowerRight" "R90" "stick" 0.0625 nil)
schCreatePin(cv nil "VREFPF1" "inputOutput" nil '(34.999 -0.750) "R90")
schCreateWire(cv "route" "full" '((34.938 0.875) (34.938 1.625)) 0 0 0 nil nil)
schCreateWireLabel(cv nil '(34.938 1.125) "VSSCAL" "lowerLeft" "R90" "stick" 0.0625 nil)
schCreateWire(cv "route" "full" '((35.312 0.875) (35.312 1.625)) 0 0 0 nil nil)
schCreateWireLabel(cv nil '(35.312 1.125) "GIOL" "lowerLeft" "R90" "stick" 0.0625 nil)
schCreateWire(cv "route" "full" '((34.562 0.875) (34.562 1.625)) 0 0 0 nil nil)
schCreateWireLabel(cv nil '(34.562 1.125) "VDDCAL" "lowerLeft" "R90" "stick" 0.0625 nil)
dbCreateInst(cv pdb3ac_v_gMaster "VREFP1_bottom17" '(37.1875 0) "R0")
schCreateWire(cv "route" "full" '((36.999 0.000) (36.999 -0.750)) 0 0 0 nil nil)
schCreateWireLabel(cv nil '(36.999 -0.250) "VREFP1" "lowerRight" "R90" "stick" 0.0625 nil)
schCreatePin(cv nil "VREFP1" "inputOutput" nil '(36.999 -0.750) "R90")
schCreateWire(cv "route" "full" '((36.938 0.875) (36.938 1.625)) 0 0 0 nil nil)
schCreateWireLabel(cv nil '(36.938 1.125) "VSSCAL" "lowerLeft" "R90" "stick" 0.0625 nil)
schCreateWire(cv "route" "full" '((37.312 0.875) (37.312 1.625)) 0 0 0 nil nil)
schCreateWireLabel(cv nil '(37.312 1.125) "GIOL" "lowerLeft" "R90" "stick" 0.0625 nil)
schCreateWire(cv "route" "full" '((36.562 0.875) (36.562 1.625)) 0 0 0 nil nil)
schCreateWireLabel(cv nil '(36.562 1.125) "VDDCAL" "lowerLeft" "R90" "stick" 0.0625 nil)
dbCreateInst(cv pdb3ac_v_gMaster "VREFN1_bottom18" '(39.1875 0) "R0")
schCreateWire(cv "route" "full" '((38.999 0.000) (38.999 -0.750)) 0 0 0 nil nil)
schCreateWireLabel(cv nil '(38.999 -0.250) "VREFN1" "lowerRight" "R90" "stick" 0.0625 nil)
schCreatePin(cv nil "VREFN1" "inputOutput" nil '(38.999 -0.750) "R90")
schCreateWire(cv "route" "full" '((38.938 0.875) (38.938 1.625)) 0 0 0 nil nil)
schCreateWireLabel(cv nil '(38.938 1.125) "VSSCAL" "lowerLeft" "R90" "stick" 0.0625 nil)
schCreateWire(cv "route" "full" '((39.312 0.875) (39.312 1.625)) 0 0 0 nil nil)
schCreateWireLabel(cv nil '(39.312 1.125) "GIOL" "lowerLeft" "R90" "stick" 0.0625 nil)
schCreateWire(cv "route" "full" '((38.562 0.875) (38.562 1.625)) 0 0 0 nil nil)
schCreateWireLabel(cv nil '(38.562 1.125) "VDDCAL" "lowerLeft" "R90" "stick" 0.0625 nil)
dbCreateInst(cv pvss1ac_v_gMaster "AVSS1_bottom19" '(41.1875 0) "R0")
schCreateWire(cv "route" "full" '((40.999 0.000) (40.999 -0.750)) 0 0 0 nil nil)
schCreateWireLabel(cv nil '(40.999 -0.250) "AVSS1" "lowerRight" "R90" "stick" 0.0625 nil)
schCreatePin(cv nil "AVSS1" "inputOutput" nil '(40.999 -0.750) "R90")
schCreateWire(cv "route" "full" '((40.938 0.875) (40.938 1.625)) 0 0 0 nil nil)
schCreateWireLabel(cv nil '(40.938 1.125) "VSSCAL" "lowerLeft" "R90" "stick" 0.0625 nil)
schCreateWire(cv "route" "full" '((41.312 0.875) (41.312 1.625)) 0 0 0 nil nil)
schCreateWireLabel(cv nil '(41.312 1.125) "GIOL" "lowerLeft" "R90" "stick" 0.0625 nil)
schCreateWire(cv "route" "full" '((40.562 0.875) (40.562 1.625)) 0 0 0 nil nil)
schCreateWireLabel(cv nil '(40.562 1.125) "VDDCAL" "lowerLeft" "R90" "stick" 0.0625 nil)
dbCreateInst(cv pvss1ac_v_gMaster "AVSS1_bottom20" '(43.1875 0) "R0")
schCreateWire(cv "route" "full" '((42.999 0.000) (42.999 -0.750)) 0 0 0 nil nil)
schCreateWireLabel(cv nil '(42.999 -0.250) "AVSS1" "lowerRight" "R90" "stick" 0.0625 nil)
schCreatePin(cv nil "AVSS1" "inputOutput" nil '(42.999 -0.750) "R90")
schCreateWire(cv "route" "full" '((42.938 0.875) (42.938 1.625)) 0 0 0 nil nil)
schCreateWireLabel(cv nil '(42.938 1.125) "VSSCAL" "lowerLeft" "R90" "stick" 0.0625 nil)
schCreateWire(cv "route" "full" '((43.312 0.875) (43.312 1.625)) 0 0 0 nil nil)
schCreateWireLabel(cv nil '(43.312 1.125) "GIOL" "lowerLeft" "R90" "stick" 0.0625 nil)
schCreateWire(cv "route" "full" '((42.562 0.875) (42.562 1.625)) 0 0 0 nil nil)
schCreateWireLabel(cv nil '(42.562 1.125) "VDDCAL" "lowerLeft" "R90" "stick" 0.0625 nil)
dbCreateInst(cv pvdd1ac_v_gMaster "AVDDH1_bottom21" '(45.1875 0) "R0")
schCreateWire(cv "route" "full" '((44.938 0.875) (44.938 1.625)) 0 0 0 nil nil)
schCreateWireLabel(cv nil '(44.938 1.125) "VSSCAL" "lowerLeft" "R90" "stick" 0.0625 nil)
schCreateWire(cv "route" "full" '((45.312 0.875) (45.312 1.625)) 0 0 0 nil nil)
schCreateWireLabel(cv nil '(45.312 1.125) "GIOL" "lowerLeft" "R90" "stick" 0.0625 nil)
schCreateWire(cv "route" "full" '((44.999 0.000) (44.999 -0.750)) 0 0 0 nil nil)
schCreateWireLabel(cv nil '(44.999 -0.250) "AVDDH1" "lowerRight" "R90" "stick" 0.0625 nil)
schCreatePin(cv nil "AVDDH1" "inputOutput" nil '(44.999 -0.750) "R90")
schCreateWire(cv "route" "full" '((44.562 0.875) (44.562 1.625)) 0 0 0 nil nil)
schCreateWireLabel(cv nil '(44.562 1.125) "VDDCAL" "lowerLeft" "R90" "stick" 0.0625 nil)
dbCreateInst(cv pvdd1ac_v_gMaster "AVDDH1_bottom22" '(47.1875 0) "R0")
schCreateWire(cv "route" "full" '((46.938 0.875) (46.938 1.625)) 0 0 0 nil nil)
schCreateWireLabel(cv nil '(46.938 1.125) "VSSCAL" "lowerLeft" "R90" "stick" 0.0625 nil)
schCreateWire(cv "route" "full" '((47.312 0.875) (47.312 1.625)) 0 0 0 nil nil)
schCreateWireLabel(cv nil '(47.312 1.125) "GIOL" "lowerLeft" "R90" "stick" 0.0625 nil)
schCreateWire(cv "route" "full" '((46.999 0.000) (46.999 -0.750)) 0 0 0 nil nil)
schCreateWireLabel(cv nil '(46.999 -0.250) "AVDDH1" "lowerRight" "R90" "stick" 0.0625 nil)
schCreatePin(cv nil "AVDDH1" "inputOutput" nil '(46.999 -0.750) "R90")
schCreateWire(cv "route" "full" '((46.562 0.875) (46.562 1.625)) 0 0 0 nil nil)
schCreateWireLabel(cv nil '(46.562 1.125) "VDDCAL" "lowerLeft" "R90" "stick" 0.0625 nil)
dbCreateInst(cv pdb3ac_v_gMaster "GIOL_bottom23" '(49.1875 0) "R0")
schCreateWire(cv "route" "full" '((48.999 0.000) (48.999 -0.750)) 0 0 0 nil nil)
schCreateWireLabel(cv nil '(48.999 -0.250) "GIOL" "lowerRight" "R90" "stick" 0.0625 nil)
schCreatePin(cv nil "GIOL" "inputOutput" nil '(48.999 -0.750) "R90")
schCreateWire(cv "route" "full" '((48.938 0.875) (48.938 1.625)) 0 0 0 nil nil)
schCreateWireLabel(cv nil '(48.938 1.125) "VSSCAL" "lowerLeft" "R90" "stick" 0.0625 nil)
schCreateWire(cv "route" "full" '((49.312 0.875) (49.312 1.625)) 0 0 0 nil nil)
schCreateWireLabel(cv nil '(49.312 1.125) "GIOL" "lowerLeft" "R90" "stick" 0.0625 nil)
schCreateWire(cv "route" "full" '((48.562 0.875) (48.562 1.625)) 0 0 0 nil nil)
schCreateWireLabel(cv nil '(48.562 1.125) "VDDCAL" "lowerLeft" "R90" "stick" 0.0625 nil)
dbCreateInst(cv pdb3ac_v_gMaster "DVSS_bottom24" '(51.1875 0) "R0")
schCreateWire(cv "route" "full" '((50.999 0.000) (50.999 -0.750)) 0 0 0 nil nil)
schCreateWireLabel(cv nil '(50.999 -0.250) "DVSS" "lowerRight" "R90" "stick" 0.0625 nil)
schCreatePin(cv nil "DVSS" "inputOutput" nil '(50.999 -0.750) "R90")
schCreateWire(cv "route" "full" '((50.938 0.875) (50.938 1.625)) 0 0 0 nil nil)
schCreateWireLabel(cv nil '(50.938 1.125) "VSSCAL" "lowerLeft" "R90" "stick" 0.0625 nil)
schCreateWire(cv "route" "full" '((51.312 0.875) (51.312 1.625)) 0 0 0 nil nil)
schCreateWireLabel(cv nil '(51.312 1.125) "GIOL" "lowerLeft" "R90" "stick" 0.0625 nil)
schCreateWire(cv "route" "full" '((50.562 0.875) (50.562 1.625)) 0 0 0 nil nil)
schCreateWireLabel(cv nil '(50.562 1.125) "VDDCAL" "lowerLeft" "R90" "stick" 0.0625 nil)
dbCreateInst(cv pdb3ac_v_gMaster "DVDD_bottom25" '(53.1875 0) "R0")
schCreateWire(cv "route" "full" '((52.999 0.000) (52.999 -0.750)) 0 0 0 nil nil)
schCreateWireLabel(cv nil '(52.999 -0.250) "DVDD" "lowerRight" "R90" "stick" 0.0625 nil)
schCreatePin(cv nil "DVDD" "inputOutput" nil '(52.999 -0.750) "R90")
schCreateWire(cv "route" "full" '((52.938 0.875) (52.938 1.625)) 0 0 0 nil nil)
schCreateWireLabel(cv nil '(52.938 1.125) "VSSCAL" "lowerLeft" "R90" "stick" 0.0625 nil)
schCreateWire(cv "route" "full" '((53.312 0.875) (53.312 1.625)) 0 0 0 nil nil)
schCreateWireLabel(cv nil '(53.312 1.125) "GIOL" "lowerLeft" "R90" "stick" 0.0625 nil)
schCreateWire(cv "route" "full" '((52.562 0.875) (52.562 1.625)) 0 0 0 nil nil)
schCreateWireLabel(cv nil '(52.562 1.125) "VDDCAL" "lowerLeft" "R90" "stick" 0.0625 nil)
dbCreateInst(cv pdb3ac_v_gMaster "VSSFIFO_bottom26" '(55.1875 0) "R0")
schCreateWire(cv "route" "full" '((54.999 0.000) (54.999 -0.750)) 0 0 0 nil nil)
schCreateWireLabel(cv nil '(54.999 -0.250) "VSSFIFO" "lowerRight" "R90" "stick" 0.0625 nil)
schCreatePin(cv nil "VSSFIFO" "inputOutput" nil '(54.999 -0.750) "R90")
schCreateWire(cv "route" "full" '((54.938 0.875) (54.938 1.625)) 0 0 0 nil nil)
schCreateWireLabel(cv nil '(54.938 1.125) "VSSCAL" "lowerLeft" "R90" "stick" 0.0625 nil)
schCreateWire(cv "route" "full" '((55.312 0.875) (55.312 1.625)) 0 0 0 nil nil)
schCreateWireLabel(cv nil '(55.312 1.125) "GIOL" "lowerLeft" "R90" "stick" 0.0625 nil)
schCreateWire(cv "route" "full" '((54.562 0.875) (54.562 1.625)) 0 0 0 nil nil)
schCreateWireLabel(cv nil '(54.562 1.125) "VDDCAL" "lowerLeft" "R90" "stick" 0.0625 nil)
dbCreateInst(cv pdb3ac_v_gMaster "VDDFIFO_bottom27" '(57.1875 0) "R0")
schCreateWire(cv "route" "full" '((56.999 0.000) (56.999 -0.750)) 0 0 0 nil nil)
schCreateWireLabel(cv nil '(56.999 -0.250) "VDDFIFO" "lowerRight" "R90" "stick" 0.0625 nil)
schCreatePin(cv nil "VDDFIFO" "inputOutput" nil '(56.999 -0.750) "R90")
schCreateWire(cv "route" "full" '((56.938 0.875) (56.938 1.625)) 0 0 0 nil nil)
schCreateWireLabel(cv nil '(56.938 1.125) "VSSCAL" "lowerLeft" "R90" "stick" 0.0625 nil)
schCreateWire(cv "route" "full" '((57.312 0.875) (57.312 1.625)) 0 0 0 nil nil)
schCreateWireLabel(cv nil '(57.312 1.125) "GIOL" "lowerLeft" "R90" "stick" 0.0625 nil)
schCreateWire(cv "route" "full" '((56.562 0.875) (56.562 1.625)) 0 0 0 nil nil)
schCreateWireLabel(cv nil '(56.562 1.125) "VDDCAL" "lowerLeft" "R90" "stick" 0.0625 nil)
dbCreateInst(cv pdb3ac_v_gMaster "VSSSPI_bottom28" '(59.1875 0) "R0")
schCreateWire(cv "route" "full" '((58.999 0.000) (58.999 -0.750)) 0 0 0 nil nil)
schCreateWireLabel(cv nil '(58.999 -0.250) "VSSSPI" "lowerRight" "R90" "stick" 0.0625 nil)
schCreatePin(cv nil "VSSSPI" "inputOutput" nil '(58.999 -0.750) "R90")
schCreateWire(cv "route" "full" '((58.938 0.875) (58.938 1.625)) 0 0 0 nil nil)
schCreateWireLabel(cv nil '(58.938 1.125) "VSSCAL" "lowerLeft" "R90" "stick" 0.0625 nil)
schCreateWire(cv "route" "full" '((59.312 0.875) (59.312 1.625)) 0 0 0 nil nil)
schCreateWireLabel(cv nil '(59.312 1.125) "GIOL" "lowerLeft" "R90" "stick" 0.0625 nil)
schCreateWire(cv "route" "full" '((58.562 0.875) (58.562 1.625)) 0 0 0 nil nil)
schCreateWireLabel(cv nil '(58.562 1.125) "VDDCAL" "lowerLeft" "R90" "stick" 0.0625 nil)
dbCreateInst(cv pdb3ac_h_gMaster "VDDSPI_right0" '(62.0 3.1875) "R90")
schCreateWire(cv "route" "full" '((62.000 2.999) (62.750 2.999)) 0 0 0 nil nil)
schCreateWireLabel(cv nil '(62.250 2.999) "VDDSPI" "lowerLeft" "R0" "stick" 0.0625 nil)
schCreatePin(cv nil "VDDSPI" "inputOutput" nil '(62.750 2.999) "R180")
schCreateWire(cv "route" "full" '((61.125 2.938) (60.375 2.938)) 0 0 0 nil nil)
schCreateWireLabel(cv nil '(60.875 2.938) "VSSCAL" "lowerRight" "R0" "stick" 0.0625 nil)
schCreateWire(cv "route" "full" '((61.125 3.312) (60.375 3.312)) 0 0 0 nil nil)
schCreateWireLabel(cv nil '(60.875 3.312) "GIOL" "lowerRight" "R0" "stick" 0.0625 nil)
schCreateWire(cv "route" "full" '((61.125 2.562) (60.375 2.562)) 0 0 0 nil nil)
schCreateWireLabel(cv nil '(60.875 2.562) "VDDCAL" "lowerRight" "R0" "stick" 0.0625 nil)
dbCreateInst(cv pdb3ac_h_gMaster "FVSS_right1" '(62.0 5.1875) "R90")
schCreateWire(cv "route" "full" '((62.000 5.000) (62.750 5.000)) 0 0 0 nil nil)
schCreateWireLabel(cv nil '(62.250 5.000) "FVSS" "lowerLeft" "R0" "stick" 0.0625 nil)
schCreatePin(cv nil "FVSS" "inputOutput" nil '(62.750 5.000) "R180")
schCreateWire(cv "route" "full" '((61.125 4.938) (60.375 4.938)) 0 0 0 nil nil)
schCreateWireLabel(cv nil '(60.875 4.938) "VSSCAL" "lowerRight" "R0" "stick" 0.0625 nil)
schCreateWire(cv "route" "full" '((61.125 5.312) (60.375 5.312)) 0 0 0 nil nil)
schCreateWireLabel(cv nil '(60.875 5.312) "GIOL" "lowerRight" "R0" "stick" 0.0625 nil)
schCreateWire(cv "route" "full" '((61.125 4.562) (60.375 4.562)) 0 0 0 nil nil)
schCreateWireLabel(cv nil '(60.875 4.562) "VDDCAL" "lowerRight" "R0" "stick" 0.0625 nil)
dbCreateInst(cv pdb3ac_h_gMaster "FVDDH_right2" '(62.0 7.1875) "R90")
schCreateWire(cv "route" "full" '((62.000 7.000) (62.750 7.000)) 0 0 0 nil nil)
schCreateWireLabel(cv nil '(62.250 7.000) "FVDDH" "lowerLeft" "R0" "stick" 0.0625 nil)
schCreatePin(cv nil "FVDDH" "inputOutput" nil '(62.750 7.000) "R180")
schCreateWire(cv "route" "full" '((61.125 6.938) (60.375 6.938)) 0 0 0 nil nil)
schCreateWireLabel(cv nil '(60.875 6.938) "VSSCAL" "lowerRight" "R0" "stick" 0.0625 nil)
schCreateWire(cv "route" "full" '((61.125 7.312) (60.375 7.312)) 0 0 0 nil nil)
schCreateWireLabel(cv nil '(60.875 7.312) "GIOL" "lowerRight" "R0" "stick" 0.0625 nil)
schCreateWire(cv "route" "full" '((61.125 6.562) (60.375 6.562)) 0 0 0 nil nil)
schCreateWireLabel(cv nil '(60.875 6.562) "VDDCAL" "lowerRight" "R0" "stick" 0.0625 nil)
dbCreateInst(cv pdb3ac_h_gMaster "FVDD_right3" '(62.0 9.1875) "R90")
schCreateWire(cv "route" "full" '((62.000 8.999) (62.750 8.999)) 0 0 0 nil nil)
schCreateWireLabel(cv nil '(62.250 8.999) "FVDD" "lowerLeft" "R0" "stick" 0.0625 nil)
schCreatePin(cv nil "FVDD" "inputOutput" nil '(62.750 8.999) "R180")
schCreateWire(cv "route" "full" '((61.125 8.938) (60.375 8.938)) 0 0 0 nil nil)
schCreateWireLabel(cv nil '(60.875 8.938) "VSSCAL" "lowerRight" "R0" "stick" 0.0625 nil)
schCreateWire(cv "route" "full" '((61.125 9.312) (60.375 9.312)) 0 0 0 nil nil)
schCreateWireLabel(cv nil '(60.875 9.312) "GIOL" "lowerRight" "R0" "stick" 0.0625 nil)
schCreateWire(cv "route" "full" '((61.125 8.562) (60.375 8.562)) 0 0 0 nil nil)
schCreateWireLabel(cv nil '(60.875 8.562) "VDDCAL" "lowerRight" "R0" "stick" 0.0625 nil)
dbCreateInst(cv pdb3ac_h_gMaster "VREFNF3_right4" '(62.0 11.1875) "R90")
schCreateWire(cv "route" "full" '((62.000 10.999) (62.750 10.999)) 0 0 0 nil nil)
schCreateWireLabel(cv nil '(62.250 10.999) "VREFNF3" "lowerLeft" "R0" "stick" 0.0625 nil)
schCreatePin(cv nil "VREFNF3" "inputOutput" nil '(62.750 10.999) "R180")
schCreateWire(cv "route" "full" '((61.125 10.938) (60.375 10.938)) 0 0 0 nil nil)
schCreateWireLabel(cv nil '(60.875 10.938) "VSSCAL" "lowerRight" "R0" "stick" 0.0625 nil)
schCreateWire(cv "route" "full" '((61.125 11.312) (60.375 11.312)) 0 0 0 nil nil)
schCreateWireLabel(cv nil '(60.875 11.312) "GIOL" "lowerRight" "R0" "stick" 0.0625 nil)
schCreateWire(cv "route" "full" '((61.125 10.562) (60.375 10.562)) 0 0 0 nil nil)
schCreateWireLabel(cv nil '(60.875 10.562) "VDDCAL" "lowerRight" "R0" "stick" 0.0625 nil)
dbCreateInst(cv pdb3ac_h_gMaster "VREFPF3_right5" '(62.0 13.1875) "R90")
schCreateWire(cv "route" "full" '((62.000 12.999) (62.750 12.999)) 0 0 0 nil nil)
schCreateWireLabel(cv nil '(62.250 12.999) "VREFPF3" "lowerLeft" "R0" "stick" 0.0625 nil)
schCreatePin(cv nil "VREFPF3" "inputOutput" nil '(62.750 12.999) "R180")
schCreateWire(cv "route" "full" '((61.125 12.938) (60.375 12.938)) 0 0 0 nil nil)
schCreateWireLabel(cv nil '(60.875 12.938) "VSSCAL" "lowerRight" "R0" "stick" 0.0625 nil)
schCreateWire(cv "route" "full" '((61.125 13.312) (60.375 13.312)) 0 0 0 nil nil)
schCreateWireLabel(cv nil '(60.875 13.312) "GIOL" "lowerRight" "R0" "stick" 0.0625 nil)
schCreateWire(cv "route" "full" '((61.125 12.562) (60.375 12.562)) 0 0 0 nil nil)
schCreateWireLabel(cv nil '(60.875 12.562) "VDDCAL" "lowerRight" "R0" "stick" 0.0625 nil)
dbCreateInst(cv pdb3ac_h_gMaster "VREFP3_right6" '(62.0 15.1875) "R90")
schCreateWire(cv "route" "full" '((62.000 14.999) (62.750 14.999)) 0 0 0 nil nil)
schCreateWireLabel(cv nil '(62.250 14.999) "VREFP3" "lowerLeft" "R0" "stick" 0.0625 nil)
schCreatePin(cv nil "VREFP3" "inputOutput" nil '(62.750 14.999) "R180")
schCreateWire(cv "route" "full" '((61.125 14.938) (60.375 14.938)) 0 0 0 nil nil)
schCreateWireLabel(cv nil '(60.875 14.938) "VSSCAL" "lowerRight" "R0" "stick" 0.0625 nil)
schCreateWire(cv "route" "full" '((61.125 15.312) (60.375 15.312)) 0 0 0 nil nil)
schCreateWireLabel(cv nil '(60.875 15.312) "GIOL" "lowerRight" "R0" "stick" 0.0625 nil)
schCreateWire(cv "route" "full" '((61.125 14.562) (60.375 14.562)) 0 0 0 nil nil)
schCreateWireLabel(cv nil '(60.875 14.562) "VDDCAL" "lowerRight" "R0" "stick" 0.0625 nil)
dbCreateInst(cv pdb3ac_h_gMaster "VREFN3_right7" '(62.0 17.1875) "R90")
schCreateWire(cv "route" "full" '((62.000 17.000) (62.750 17.000)) 0 0 0 nil nil)
schCreateWireLabel(cv nil '(62.250 17.000) "VREFN3" "lowerLeft" "R0" "stick" 0.0625 nil)
schCreatePin(cv nil "VREFN3" "inputOutput" nil '(62.750 17.000) "R180")
schCreateWire(cv "route" "full" '((61.125 16.938) (60.375 16.938)) 0 0 0 nil nil)
schCreateWireLabel(cv nil '(60.875 16.938) "VSSCAL" "lowerRight" "R0" "stick" 0.0625 nil)
schCreateWire(cv "route" "full" '((61.125 17.312) (60.375 17.312)) 0 0 0 nil nil)
schCreateWireLabel(cv nil '(60.875 17.312) "GIOL" "lowerRight" "R0" "stick" 0.0625 nil)
schCreateWire(cv "route" "full" '((61.125 16.562) (60.375 16.562)) 0 0 0 nil nil)
schCreateWireLabel(cv nil '(60.875 16.562) "VDDCAL" "lowerRight" "R0" "stick" 0.0625 nil)
dbCreateInst(cv pvdd1ac_h_gMaster "AVDDH3_right8" '(62.0 19.1875) "R90")
schCreateWire(cv "route" "full" '((61.125 18.938) (60.375 18.938)) 0 0 0 nil nil)
schCreateWireLabel(cv nil '(60.875 18.938) "VSSCAL" "lowerRight" "R0" "stick" 0.0625 nil)
schCreateWire(cv "route" "full" '((61.125 19.312) (60.375 19.312)) 0 0 0 nil nil)
schCreateWireLabel(cv nil '(60.875 19.312) "GIOL" "lowerRight" "R0" "stick" 0.0625 nil)
schCreateWire(cv "route" "full" '((62.000 19.000) (62.750 19.000)) 0 0 0 nil nil)
schCreateWireLabel(cv nil '(62.250 19.000) "AVDDH3" "lowerLeft" "R0" "stick" 0.0625 nil)
schCreatePin(cv nil "AVDDH3" "inputOutput" nil '(62.750 19.000) "R180")
schCreateWire(cv "route" "full" '((61.125 18.562) (60.375 18.562)) 0 0 0 nil nil)
schCreateWireLabel(cv nil '(60.875 18.562) "VDDCAL" "lowerRight" "R0" "stick" 0.0625 nil)
dbCreateInst(cv pvdd1ac_h_gMaster "AVDDH3_right9" '(62.0 21.1875) "R90")
schCreateWire(cv "route" "full" '((61.125 20.938) (60.375 20.938)) 0 0 0 nil nil)
schCreateWireLabel(cv nil '(60.875 20.938) "VSSCAL" "lowerRight" "R0" "stick" 0.0625 nil)
schCreateWire(cv "route" "full" '((61.125 21.312) (60.375 21.312)) 0 0 0 nil nil)
schCreateWireLabel(cv nil '(60.875 21.312) "GIOL" "lowerRight" "R0" "stick" 0.0625 nil)
schCreateWire(cv "route" "full" '((62.000 21.000) (62.750 21.000)) 0 0 0 nil nil)
schCreateWireLabel(cv nil '(62.250 21.000) "AVDDH3" "lowerLeft" "R0" "stick" 0.0625 nil)
schCreatePin(cv nil "AVDDH3" "inputOutput" nil '(62.750 21.000) "R180")
schCreateWire(cv "route" "full" '((61.125 20.562) (60.375 20.562)) 0 0 0 nil nil)
schCreateWireLabel(cv nil '(60.875 20.562) "VDDCAL" "lowerRight" "R0" "stick" 0.0625 nil)
dbCreateInst(cv pvss1ac_h_gMaster "AVSS3_right10" '(62.0 23.1875) "R90")
schCreateWire(cv "route" "full" '((62.000 23.000) (62.750 23.000)) 0 0 0 nil nil)
schCreateWireLabel(cv nil '(62.250 23.000) "AVSS3" "lowerLeft" "R0" "stick" 0.0625 nil)
schCreatePin(cv nil "AVSS3" "inputOutput" nil '(62.750 23.000) "R180")
schCreateWire(cv "route" "full" '((61.125 22.938) (60.375 22.938)) 0 0 0 nil nil)
schCreateWireLabel(cv nil '(60.875 22.938) "VSSCAL" "lowerRight" "R0" "stick" 0.0625 nil)
schCreateWire(cv "route" "full" '((61.125 23.312) (60.375 23.312)) 0 0 0 nil nil)
schCreateWireLabel(cv nil '(60.875 23.312) "GIOL" "lowerRight" "R0" "stick" 0.0625 nil)
schCreateWire(cv "route" "full" '((61.125 22.562) (60.375 22.562)) 0 0 0 nil nil)
schCreateWireLabel(cv nil '(60.875 22.562) "VDDCAL" "lowerRight" "R0" "stick" 0.0625 nil)
dbCreateInst(cv pvss1ac_h_gMaster "AVSS3_right11" '(62.0 25.1875) "R90")
schCreateWire(cv "route" "full" '((62.000 25.000) (62.750 25.000)) 0 0 0 nil nil)
schCreateWireLabel(cv nil '(62.250 25.000) "AVSS3" "lowerLeft" "R0" "stick" 0.0625 nil)
schCreatePin(cv nil "AVSS3" "inputOutput" nil '(62.750 25.000) "R180")
schCreateWire(cv "route" "full" '((61.125 24.938) (60.375 24.938)) 0 0 0 nil nil)
schCreateWireLabel(cv nil '(60.875 24.938) "VSSCAL" "lowerRight" "R0" "stick" 0.0625 nil)
schCreateWire(cv "route" "full" '((61.125 25.312) (60.375 25.312)) 0 0 0 nil nil)
schCreateWireLabel(cv nil '(60.875 25.312) "GIOL" "lowerRight" "R0" "stick" 0.0625 nil)
schCreateWire(cv "route" "full" '((61.125 24.562) (60.375 24.562)) 0 0 0 nil nil)
schCreateWireLabel(cv nil '(60.875 24.562) "VDDCAL" "lowerRight" "R0" "stick" 0.0625 nil)
dbCreateInst(cv pdb3ac_h_gMaster "IBOTA3_right12" '(62.0 27.1875) "R90")
schCreateWire(cv "route" "full" '((62.000 27.000) (62.750 27.000)) 0 0 0 nil nil)
schCreateWireLabel(cv nil '(62.250 27.000) "IBOTA3" "lowerLeft" "R0" "stick" 0.0625 nil)
schCreatePin(cv nil "IBOTA3" "inputOutput" nil '(62.750 27.000) "R180")
schCreateWire(cv "route" "full" '((61.125 26.938) (60.375 26.938)) 0 0 0 nil nil)
schCreateWireLabel(cv nil '(60.875 26.938) "VSSCAL" "lowerRight" "R0" "stick" 0.0625 nil)
schCreateWire(cv "route" "full" '((61.125 27.312) (60.375 27.312)) 0 0 0 nil nil)
schCreateWireLabel(cv nil '(60.875 27.312) "GIOL" "lowerRight" "R0" "stick" 0.0625 nil)
schCreateWire(cv "route" "full" '((61.125 26.562) (60.375 26.562)) 0 0 0 nil nil)
schCreateWireLabel(cv nil '(60.875 26.562) "VDDCAL" "lowerRight" "R0" "stick" 0.0625 nil)
dbCreateInst(cv pvdd1ac_h_gMaster "AVDDVCO_right13" '(62.0 29.1875) "R90")
schCreateWire(cv "route" "full" '((61.125 28.938) (60.375 28.938)) 0 0 0 nil nil)
schCreateWireLabel(cv nil '(60.875 28.938) "VSSCAL" "lowerRight" "R0" "stick" 0.0625 nil)
schCreateWire(cv "route" "full" '((61.125 29.312) (60.375 29.312)) 0 0 0 nil nil)
schCreateWireLabel(cv nil '(60.875 29.312) "GIOL" "lowerRight" "R0" "stick" 0.0625 nil)
schCreateWire(cv "route" "full" '((62.000 29.000) (62.750 29.000)) 0 0 0 nil nil)
schCreateWireLabel(cv nil '(62.250 29.000) "AVDDVCO" "lowerLeft" "R0" "stick" 0.0625 nil)
schCreatePin(cv nil "AVDDVCO" "inputOutput" nil '(62.750 29.000) "R180")
schCreateWire(cv "route" "full" '((61.125 28.562) (60.375 28.562)) 0 0 0 nil nil)
schCreateWireLabel(cv nil '(60.875 28.562) "VDDCAL" "lowerRight" "R0" "stick" 0.0625 nil)
dbCreateInst(cv pdb3ac_h_gMaster "IBV2IA_right14" '(62.0 31.1875) "R90")
schCreateWire(cv "route" "full" '((62.000 31.000) (62.750 31.000)) 0 0 0 nil nil)
schCreateWireLabel(cv nil '(62.250 31.000) "IBV2IA" "lowerLeft" "R0" "stick" 0.0625 nil)
schCreatePin(cv nil "IBV2IA" "inputOutput" nil '(62.750 31.000) "R180")
schCreateWire(cv "route" "full" '((61.125 30.938) (60.375 30.938)) 0 0 0 nil nil)
schCreateWireLabel(cv nil '(60.875 30.938) "VSSCAL" "lowerRight" "R0" "stick" 0.0625 nil)
schCreateWire(cv "route" "full" '((61.125 31.312) (60.375 31.312)) 0 0 0 nil nil)
schCreateWireLabel(cv nil '(60.875 31.312) "GIOL" "lowerRight" "R0" "stick" 0.0625 nil)
schCreateWire(cv "route" "full" '((61.125 30.562) (60.375 30.562)) 0 0 0 nil nil)
schCreateWireLabel(cv nil '(60.875 30.562) "VDDCAL" "lowerRight" "R0" "stick" 0.0625 nil)
dbCreateInst(cv pdb3ac_h_gMaster "IBV2I_right15" '(62.0 33.1875) "R90")
schCreateWire(cv "route" "full" '((62.000 32.999) (62.750 32.999)) 0 0 0 nil nil)
schCreateWireLabel(cv nil '(62.250 32.999) "IBV2I" "lowerLeft" "R0" "stick" 0.0625 nil)
schCreatePin(cv nil "IBV2I" "inputOutput" nil '(62.750 32.999) "R180")
schCreateWire(cv "route" "full" '((61.125 32.938) (60.375 32.938)) 0 0 0 nil nil)
schCreateWireLabel(cv nil '(60.875 32.938) "VSSCAL" "lowerRight" "R0" "stick" 0.0625 nil)
schCreateWire(cv "route" "full" '((61.125 33.312) (60.375 33.312)) 0 0 0 nil nil)
schCreateWireLabel(cv nil '(60.875 33.312) "GIOL" "lowerRight" "R0" "stick" 0.0625 nil)
schCreateWire(cv "route" "full" '((61.125 32.562) (60.375 32.562)) 0 0 0 nil nil)
schCreateWireLabel(cv nil '(60.875 32.562) "VDDCAL" "lowerRight" "R0" "stick" 0.0625 nil)
dbCreateInst(cv pvss1ac_v_gMaster "AVSSVCO_top0" '(58.8125 36.0) "R180")
schCreateWire(cv "route" "full" '((59.001 36.000) (59.001 36.750)) 0 0 0 nil nil)
schCreateWireLabel(cv nil '(59.001 36.250) "AVSSVCO" "lowerLeft" "R90" "stick" 0.0625 nil)
schCreatePin(cv nil "AVSSVCO" "inputOutput" nil '(59.001 36.750) "R270")
schCreateWire(cv "route" "full" '((59.062 35.125) (59.062 34.375)) 0 0 0 nil nil)
schCreateWireLabel(cv nil '(59.062 34.875) "VSSCAL" "lowerRight" "R90" "stick" 0.0625 nil)
schCreateWire(cv "route" "full" '((58.688 35.125) (58.688 34.375)) 0 0 0 nil nil)
schCreateWireLabel(cv nil '(58.688 34.875) "GIOL" "lowerRight" "R90" "stick" 0.0625 nil)
schCreateWire(cv "route" "full" '((59.438 35.125) (59.438 34.375)) 0 0 0 nil nil)
schCreateWireLabel(cv nil '(59.438 34.875) "VDDCAL" "lowerRight" "R90" "stick" 0.0625 nil)
dbCreateInst(cv pvdd1ac_v_gMaster "VDDBUF_top1" '(56.8125 36.0) "R180")
schCreateWire(cv "route" "full" '((57.062 35.125) (57.062 34.375)) 0 0 0 nil nil)
schCreateWireLabel(cv nil '(57.062 34.875) "VSSCAL" "lowerRight" "R90" "stick" 0.0625 nil)
schCreateWire(cv "route" "full" '((56.688 35.125) (56.688 34.375)) 0 0 0 nil nil)
schCreateWireLabel(cv nil '(56.688 34.875) "GIOL" "lowerRight" "R90" "stick" 0.0625 nil)
schCreateWire(cv "route" "full" '((57.001 36.000) (57.001 36.750)) 0 0 0 nil nil)
schCreateWireLabel(cv nil '(57.001 36.250) "VDDBUF" "lowerLeft" "R90" "stick" 0.0625 nil)
schCreatePin(cv nil "VDDBUF" "inputOutput" nil '(57.001 36.750) "R270")
schCreateWire(cv "route" "full" '((57.438 35.125) (57.438 34.375)) 0 0 0 nil nil)
schCreateWireLabel(cv nil '(57.438 34.875) "VDDCAL" "lowerRight" "R90" "stick" 0.0625 nil)
dbCreateInst(cv pdb3ac_v_gMaster "DVSS_top2" '(54.8125 36.0) "R180")
schCreateWire(cv "route" "full" '((55.001 36.000) (55.001 36.750)) 0 0 0 nil nil)
schCreateWireLabel(cv nil '(55.001 36.250) "DVSS" "lowerLeft" "R90" "stick" 0.0625 nil)
schCreatePin(cv nil "DVSS" "inputOutput" nil '(55.001 36.750) "R270")
schCreateWire(cv "route" "full" '((55.062 35.125) (55.062 34.375)) 0 0 0 nil nil)
schCreateWireLabel(cv nil '(55.062 34.875) "VSSCAL" "lowerRight" "R90" "stick" 0.0625 nil)
schCreateWire(cv "route" "full" '((54.688 35.125) (54.688 34.375)) 0 0 0 nil nil)
schCreateWireLabel(cv nil '(54.688 34.875) "GIOL" "lowerRight" "R90" "stick" 0.0625 nil)
schCreateWire(cv "route" "full" '((55.438 35.125) (55.438 34.375)) 0 0 0 nil nil)
schCreateWireLabel(cv nil '(55.438 34.875) "VDDCAL" "lowerRight" "R90" "stick" 0.0625 nil)
dbCreateInst(cv pdb3ac_v_gMaster "DVDD_top3" '(52.8125 36.0) "R180")
schCreateWire(cv "route" "full" '((53.001 36.000) (53.001 36.750)) 0 0 0 nil nil)
schCreateWireLabel(cv nil '(53.001 36.250) "DVDD" "lowerLeft" "R90" "stick" 0.0625 nil)
schCreatePin(cv nil "DVDD" "inputOutput" nil '(53.001 36.750) "R270")
schCreateWire(cv "route" "full" '((53.062 35.125) (53.062 34.375)) 0 0 0 nil nil)
schCreateWireLabel(cv nil '(53.062 34.875) "VSSCAL" "lowerRight" "R90" "stick" 0.0625 nil)
schCreateWire(cv "route" "full" '((52.688 35.125) (52.688 34.375)) 0 0 0 nil nil)
schCreateWireLabel(cv nil '(52.688 34.875) "GIOL" "lowerRight" "R90" "stick" 0.0625 nil)
schCreateWire(cv "route" "full" '((53.438 35.125) (53.438 34.375)) 0 0 0 nil nil)
schCreateWireLabel(cv nil '(53.438 34.875) "VDDCAL" "lowerRight" "R90" "stick" 0.0625 nil)
dbCreateInst(cv pdb3ac_v_gMaster "VDDFIFO_top4" '(50.8125 36.0) "R180")
schCreateWire(cv "route" "full" '((51.001 36.000) (51.001 36.750)) 0 0 0 nil nil)
schCreateWireLabel(cv nil '(51.001 36.250) "VDDFIFO" "lowerLeft" "R90" "stick" 0.0625 nil)
schCreatePin(cv nil "VDDFIFO" "inputOutput" nil '(51.001 36.750) "R270")
schCreateWire(cv "route" "full" '((51.062 35.125) (51.062 34.375)) 0 0 0 nil nil)
schCreateWireLabel(cv nil '(51.062 34.875) "VSSCAL" "lowerRight" "R90" "stick" 0.0625 nil)
schCreateWire(cv "route" "full" '((50.688 35.125) (50.688 34.375)) 0 0 0 nil nil)
schCreateWireLabel(cv nil '(50.688 34.875) "GIOL" "lowerRight" "R90" "stick" 0.0625 nil)
schCreateWire(cv "route" "full" '((51.438 35.125) (51.438 34.375)) 0 0 0 nil nil)
schCreateWireLabel(cv nil '(51.438 34.875) "VDDCAL" "lowerRight" "R90" "stick" 0.0625 nil)
dbCreateInst(cv pdb3ac_v_gMaster "VSSFIFO_top5" '(48.8125 36.0) "R180")
schCreateWire(cv "route" "full" '((49.001 36.000) (49.001 36.750)) 0 0 0 nil nil)
schCreateWireLabel(cv nil '(49.001 36.250) "VSSFIFO" "lowerLeft" "R90" "stick" 0.0625 nil)
schCreatePin(cv nil "VSSFIFO" "inputOutput" nil '(49.001 36.750) "R270")
schCreateWire(cv "route" "full" '((49.062 35.125) (49.062 34.375)) 0 0 0 nil nil)
schCreateWireLabel(cv nil '(49.062 34.875) "VSSCAL" "lowerRight" "R90" "stick" 0.0625 nil)
schCreateWire(cv "route" "full" '((48.688 35.125) (48.688 34.375)) 0 0 0 nil nil)
schCreateWireLabel(cv nil '(48.688 34.875) "GIOL" "lowerRight" "R90" "stick" 0.0625 nil)
schCreateWire(cv "route" "full" '((49.438 35.125) (49.438 34.375)) 0 0 0 nil nil)
schCreateWireLabel(cv nil '(49.438 34.875) "VDDCAL" "lowerRight" "R90" "stick" 0.0625 nil)
pvss1dgz_v_gMaster = dbOpenCellView("tphn28hpcpgv18" "PVSS1DGZ_V_G" "symbol")
dbCreateInst(cv pvss1dgz_v_gMaster "GIOL_top6" '(48.0 36.0) "R180")
schCreateWire(cv "route" "full" '((47.625 35.000) (47.625 34.250)) 0 0 0 nil nil)
schCreateWireLabel(cv nil '(47.625 34.750) "POC" "lowerRight" "R90" "stick" 0.0625 nil)
schCreateWire(cv "route" "full" '((47.438 35.000) (47.438 34.250)) 0 0 0 nil nil)
schCreateWireLabel(cv nil '(47.438 34.750) "VIOL" "lowerRight" "R90" "stick" 0.0625 nil)
schCreateWire(cv "route" "full" '((47.000 36.000) (47.000 36.750)) 0 0 0 nil nil)
schCreateWireLabel(cv nil '(47.000 36.250) "GIOL" "lowerLeft" "R90" "stick" 0.0625 nil)
schCreatePin(cv nil "GIOL" "inputOutput" nil '(47.000 36.750) "R270")
schCreateWire(cv "route" "full" '((47.062 35.000) (47.062 34.250)) 0 0 0 nil nil)
schCreateWireLabel(cv nil '(47.062 34.750) "VIOH" "lowerRight" "R90" "stick" 0.0625 nil)
schCreateWire(cv "route" "full" '((46.688 35.000) (46.688 34.250)) 0 0 0 nil nil)
schCreateWireLabel(cv nil '(46.688 34.750) "GIOH" "lowerRight" "R90" "stick" 0.0625 nil)
pvdd1dgz_v_gMaster = dbOpenCellView("tphn28hpcpgv18" "PVDD1DGZ_V_G" "symbol")
dbCreateInst(cv pvdd1dgz_v_gMaster "VIOL_top7" '(46.0 36.0) "R180")
schCreateWire(cv "route" "full" '((45.625 35.000) (45.625 34.250)) 0 0 0 nil nil)
schCreateWireLabel(cv nil '(45.625 34.750) "POC" "lowerRight" "R90" "stick" 0.0625 nil)
schCreateWire(cv "route" "full" '((45.000 36.000) (45.000 36.750)) 0 0 0 nil nil)
schCreateWireLabel(cv nil '(45.000 36.250) "VIOL" "lowerLeft" "R90" "stick" 0.0625 nil)
schCreatePin(cv nil "VIOL" "inputOutput" nil '(45.000 36.750) "R270")
schCreateWire(cv "route" "full" '((45.250 35.000) (45.250 34.250)) 0 0 0 nil nil)
schCreateWireLabel(cv nil '(45.250 34.750) "GIOL" "lowerRight" "R90" "stick" 0.0625 nil)
schCreateWire(cv "route" "full" '((45.062 35.000) (45.062 34.250)) 0 0 0 nil nil)
schCreateWireLabel(cv nil '(45.062 34.750) "VIOH" "lowerRight" "R90" "stick" 0.0625 nil)
schCreateWire(cv "route" "full" '((44.688 35.000) (44.688 34.250)) 0 0 0 nil nil)
schCreateWireLabel(cv nil '(44.688 34.750) "GIOH" "lowerRight" "R90" "stick" 0.0625 nil)
pvdd2poc_v_gMaster = dbOpenCellView("tphn28hpcpgv18" "PVDD2POC_V_G" "symbol")
dbCreateInst(cv pvdd2poc_v_gMaster "VIOH_top8" '(44.0 36.0) "R180")
schCreateWire(cv "route" "full" '((43.625 35.000) (43.625 34.250)) 0 0 0 nil nil)
schCreateWireLabel(cv nil '(43.625 34.750) "POC" "lowerRight" "R90" "stick" 0.0625 nil)
schCreateWire(cv "route" "full" '((43.438 35.000) (43.438 34.250)) 0 0 0 nil nil)
schCreateWireLabel(cv nil '(43.438 34.750) "VIOL" "lowerRight" "R90" "stick" 0.0625 nil)
schCreateWire(cv "route" "full" '((43.250 35.000) (43.250 34.250)) 0 0 0 nil nil)
schCreateWireLabel(cv nil '(43.250 34.750) "GIOL" "lowerRight" "R90" "stick" 0.0625 nil)
schCreateWire(cv "route" "full" '((43.000 36.000) (43.000 36.750)) 0 0 0 nil nil)
schCreateWireLabel(cv nil '(43.000 36.250) "VIOH" "lowerLeft" "R90" "stick" 0.0625 nil)
schCreatePin(cv nil "VIOH" "inputOutput" nil '(43.000 36.750) "R270")
schCreateWire(cv "route" "full" '((42.688 35.000) (42.688 34.250)) 0 0 0 nil nil)
schCreateWireLabel(cv nil '(42.688 34.750) "GIOH" "lowerRight" "R90" "stick" 0.0625 nil)
pvss2dgz_v_gMaster = dbOpenCellView("tphn28hpcpgv18" "PVSS2DGZ_V_G" "symbol")
dbCreateInst(cv pvss2dgz_v_gMaster "GIOH_top9" '(42.0 36.0) "R180")
schCreateWire(cv "route" "full" '((41.625 35.000) (41.625 34.250)) 0 0 0 nil nil)
schCreateWireLabel(cv nil '(41.625 34.750) "POC" "lowerRight" "R90" "stick" 0.0625 nil)
schCreateWire(cv "route" "full" '((41.438 35.000) (41.438 34.250)) 0 0 0 nil nil)
schCreateWireLabel(cv nil '(41.438 34.750) "VIOL" "lowerRight" "R90" "stick" 0.0625 nil)
schCreateWire(cv "route" "full" '((41.250 35.000) (41.250 34.250)) 0 0 0 nil nil)
schCreateWireLabel(cv nil '(41.250 34.750) "GIOL" "lowerRight" "R90" "stick" 0.0625 nil)
schCreateWire(cv "route" "full" '((41.062 35.000) (41.062 34.250)) 0 0 0 nil nil)
schCreateWireLabel(cv nil '(41.062 34.750) "VIOH" "lowerRight" "R90" "stick" 0.0625 nil)
schCreateWire(cv "route" "full" '((41.000 36.000) (41.000 36.750)) 0 0 0 nil nil)
schCreateWireLabel(cv nil '(41.000 36.250) "GIOH" "lowerLeft" "R90" "stick" 0.0625 nil)
schCreatePin(cv nil "GIOH" "inputOutput" nil '(41.000 36.750) "R270")
pddw16sdgz_v_gMaster = dbOpenCellView("tphn28hpcpgv18" "PDDW16SDGZ_V_G" "symbol")
dbCreateInst(cv pddw16sdgz_v_gMaster "SCKI_top10" '(39.6875 36.0) "R180")
schCreateWire(cv "route" "full" '((39.562 35.000) (39.562 34.250)) 0 0 0 nil nil)
schCreateWireLabel(cv nil '(39.562 34.750) "GIOL" "lowerRight" "R90" "stick" 0.0625 nil)
schCreateWire(cv "route" "full" '((39.438 35.000) (39.438 34.250)) 0 0 0 nil nil)
schCreateWireLabel(cv nil '(39.438 34.750) "SCKI_CORE" "lowerRight" "R90" "stick" 0.0625 nil)
schCreatePin(cv nil "SCKI_CORE" "inputOutput" nil '(39.438 34.250) "R90")
schCreateWire(cv "route" "full" '((39.812 35.000) (39.812 34.250)) 0 0 0 nil nil)
schCreateWireLabel(cv nil '(39.812 34.750) "VIOL" "lowerRight" "R90" "stick" 0.0625 nil)
schCreateWire(cv "route" "full" '((39.938 35.000) (39.938 34.250)) 0 0 0 nil nil)
schCreateWireLabel(cv nil '(39.938 34.750) "GIOL" "lowerRight" "R90" "stick" 0.0625 nil)
schCreateWire(cv "route" "full" '((38.999 36.000) (38.999 36.750)) 0 0 0 nil nil)
schCreateWireLabel(cv nil '(38.999 36.250) "SCKI" "lowerLeft" "R90" "stick" 0.0625 nil)
schCreatePin(cv nil "SCKI" "inputOutput" nil '(38.999 36.750) "R270")
schCreateWire(cv "route" "full" '((39.312 35.000) (39.312 34.250)) 0 0 0 nil nil)
schCreateWireLabel(cv nil '(39.312 34.750) "POC" "lowerRight" "R90" "stick" 0.0625 nil)
schCreateWire(cv "route" "full" '((39.126 35.000) (39.126 34.250)) 0 0 0 nil nil)
schCreateWireLabel(cv nil '(39.126 34.750) "VIOL" "lowerRight" "R90" "stick" 0.0625 nil)
schCreateWire(cv "route" "full" '((38.938 35.000) (38.938 34.250)) 0 0 0 nil nil)
schCreateWireLabel(cv nil '(38.938 34.750) "GIOL" "lowerRight" "R90" "stick" 0.0625 nil)
schCreateWire(cv "route" "full" '((38.749 35.000) (38.749 34.250)) 0 0 0 nil nil)
schCreateWireLabel(cv nil '(38.749 34.750) "VIOH" "lowerRight" "R90" "stick" 0.0625 nil)
schCreateWire(cv "route" "full" '((38.376 35.000) (38.376 34.250)) 0 0 0 nil nil)
schCreateWireLabel(cv nil '(38.376 34.750) "GIOH" "lowerRight" "R90" "stick" 0.0625 nil)
dbCreateInst(cv pddw16sdgz_v_gMaster "SEL_0_top11" '(37.6875 36.0) "R180")
schCreateWire(cv "route" "full" '((37.562 35.000) (37.562 34.250)) 0 0 0 nil nil)
schCreateWireLabel(cv nil '(37.562 34.750) "GIOL" "lowerRight" "R90" "stick" 0.0625 nil)
schCreateWire(cv "route" "full" '((37.438 35.000) (37.438 34.250)) 0 0 0 nil nil)
schCreateWireLabel(cv nil '(37.438 34.750) "SEL_CORE<0>" "lowerRight" "R90" "stick" 0.0625 nil)
schCreatePin(cv nil "SEL_CORE<0>" "inputOutput" nil '(37.438 34.250) "R90")
schCreateWire(cv "route" "full" '((37.812 35.000) (37.812 34.250)) 0 0 0 nil nil)
schCreateWireLabel(cv nil '(37.812 34.750) "VIOL" "lowerRight" "R90" "stick" 0.0625 nil)
schCreateWire(cv "route" "full" '((37.938 35.000) (37.938 34.250)) 0 0 0 nil nil)
schCreateWireLabel(cv nil '(37.938 34.750) "GIOL" "lowerRight" "R90" "stick" 0.0625 nil)
schCreateWire(cv "route" "full" '((36.999 36.000) (36.999 36.750)) 0 0 0 nil nil)
schCreateWireLabel(cv nil '(36.999 36.250) "SEL<0>" "lowerLeft" "R90" "stick" 0.0625 nil)
schCreatePin(cv nil "SEL<0>" "inputOutput" nil '(36.999 36.750) "R270")
schCreateWire(cv "route" "full" '((37.312 35.000) (37.312 34.250)) 0 0 0 nil nil)
schCreateWireLabel(cv nil '(37.312 34.750) "POC" "lowerRight" "R90" "stick" 0.0625 nil)
schCreateWire(cv "route" "full" '((37.126 35.000) (37.126 34.250)) 0 0 0 nil nil)
schCreateWireLabel(cv nil '(37.126 34.750) "VIOL" "lowerRight" "R90" "stick" 0.0625 nil)
schCreateWire(cv "route" "full" '((36.938 35.000) (36.938 34.250)) 0 0 0 nil nil)
schCreateWireLabel(cv nil '(36.938 34.750) "GIOL" "lowerRight" "R90" "stick" 0.0625 nil)
schCreateWire(cv "route" "full" '((36.749 35.000) (36.749 34.250)) 0 0 0 nil nil)
schCreateWireLabel(cv nil '(36.749 34.750) "VIOH" "lowerRight" "R90" "stick" 0.0625 nil)
schCreateWire(cv "route" "full" '((36.376 35.000) (36.376 34.250)) 0 0 0 nil nil)
schCreateWireLabel(cv nil '(36.376 34.750) "GIOH" "lowerRight" "R90" "stick" 0.0625 nil)
dbCreateInst(cv pddw16sdgz_v_gMaster "SEL_1_top12" '(35.6875 36.0) "R180")
schCreateWire(cv "route" "full" '((35.562 35.000) (35.562 34.250)) 0 0 0 nil nil)
schCreateWireLabel(cv nil '(35.562 34.750) "GIOL" "lowerRight" "R90" "stick" 0.0625 nil)
schCreateWire(cv "route" "full" '((35.438 35.000) (35.438 34.250)) 0 0 0 nil nil)
schCreateWireLabel(cv nil '(35.438 34.750) "SEL_CORE<1>" "lowerRight" "R90" "stick" 0.0625 nil)
schCreatePin(cv nil "SEL_CORE<1>" "inputOutput" nil '(35.438 34.250) "R90")
schCreateWire(cv "route" "full" '((35.812 35.000) (35.812 34.250)) 0 0 0 nil nil)
schCreateWireLabel(cv nil '(35.812 34.750) "VIOL" "lowerRight" "R90" "stick" 0.0625 nil)
schCreateWire(cv "route" "full" '((35.938 35.000) (35.938 34.250)) 0 0 0 nil nil)
schCreateWireLabel(cv nil '(35.938 34.750) "GIOL" "lowerRight" "R90" "stick" 0.0625 nil)
schCreateWire(cv "route" "full" '((34.999 36.000) (34.999 36.750)) 0 0 0 nil nil)
schCreateWireLabel(cv nil '(34.999 36.250) "SEL<1>" "lowerLeft" "R90" "stick" 0.0625 nil)
schCreatePin(cv nil "SEL<1>" "inputOutput" nil '(34.999 36.750) "R270")
schCreateWire(cv "route" "full" '((35.312 35.000) (35.312 34.250)) 0 0 0 nil nil)
schCreateWireLabel(cv nil '(35.312 34.750) "POC" "lowerRight" "R90" "stick" 0.0625 nil)
schCreateWire(cv "route" "full" '((35.126 35.000) (35.126 34.250)) 0 0 0 nil nil)
schCreateWireLabel(cv nil '(35.126 34.750) "VIOL" "lowerRight" "R90" "stick" 0.0625 nil)
schCreateWire(cv "route" "full" '((34.938 35.000) (34.938 34.250)) 0 0 0 nil nil)
schCreateWireLabel(cv nil '(34.938 34.750) "GIOL" "lowerRight" "R90" "stick" 0.0625 nil)
schCreateWire(cv "route" "full" '((34.749 35.000) (34.749 34.250)) 0 0 0 nil nil)
schCreateWireLabel(cv nil '(34.749 34.750) "VIOH" "lowerRight" "R90" "stick" 0.0625 nil)
schCreateWire(cv "route" "full" '((34.376 35.000) (34.376 34.250)) 0 0 0 nil nil)
schCreateWireLabel(cv nil '(34.376 34.750) "GIOH" "lowerRight" "R90" "stick" 0.0625 nil)
dbCreateInst(cv pddw16sdgz_v_gMaster "SEL_2_top13" '(33.6875 36.0) "R180")
schCreateWire(cv "route" "full" '((33.562 35.000) (33.562 34.250)) 0 0 0 nil nil)
schCreateWireLabel(cv nil '(33.562 34.750) "GIOL" "lowerRight" "R90" "stick" 0.0625 nil)
schCreateWire(cv "route" "full" '((33.438 35.000) (33.438 34.250)) 0 0 0 nil nil)
schCreateWireLabel(cv nil '(33.438 34.750) "SEL_CORE<2>" "lowerRight" "R90" "stick" 0.0625 nil)
schCreatePin(cv nil "SEL_CORE<2>" "inputOutput" nil '(33.438 34.250) "R90")
schCreateWire(cv "route" "full" '((33.812 35.000) (33.812 34.250)) 0 0 0 nil nil)
schCreateWireLabel(cv nil '(33.812 34.750) "VIOL" "lowerRight" "R90" "stick" 0.0625 nil)
schCreateWire(cv "route" "full" '((33.938 35.000) (33.938 34.250)) 0 0 0 nil nil)
schCreateWireLabel(cv nil '(33.938 34.750) "GIOL" "lowerRight" "R90" "stick" 0.0625 nil)
schCreateWire(cv "route" "full" '((32.999 36.000) (32.999 36.750)) 0 0 0 nil nil)
schCreateWireLabel(cv nil '(32.999 36.250) "SEL<2>" "lowerLeft" "R90" "stick" 0.0625 nil)
schCreatePin(cv nil "SEL<2>" "inputOutput" nil '(32.999 36.750) "R270")
schCreateWire(cv "route" "full" '((33.312 35.000) (33.312 34.250)) 0 0 0 nil nil)
schCreateWireLabel(cv nil '(33.312 34.750) "POC" "lowerRight" "R90" "stick" 0.0625 nil)
schCreateWire(cv "route" "full" '((33.126 35.000) (33.126 34.250)) 0 0 0 nil nil)
schCreateWireLabel(cv nil '(33.126 34.750) "VIOL" "lowerRight" "R90" "stick" 0.0625 nil)
schCreateWire(cv "route" "full" '((32.938 35.000) (32.938 34.250)) 0 0 0 nil nil)
schCreateWireLabel(cv nil '(32.938 34.750) "GIOL" "lowerRight" "R90" "stick" 0.0625 nil)
schCreateWire(cv "route" "full" '((32.749 35.000) (32.749 34.250)) 0 0 0 nil nil)
schCreateWireLabel(cv nil '(32.749 34.750) "VIOH" "lowerRight" "R90" "stick" 0.0625 nil)
schCreateWire(cv "route" "full" '((32.376 35.000) (32.376 34.250)) 0 0 0 nil nil)
schCreateWireLabel(cv nil '(32.376 34.750) "GIOH" "lowerRight" "R90" "stick" 0.0625 nil)
dbCreateInst(cv pddw16sdgz_v_gMaster "TRIG_top14" '(31.6875 36.0) "R180")
schCreateWire(cv "route" "full" '((31.562 35.000) (31.562 34.250)) 0 0 0 nil nil)
schCreateWireLabel(cv nil '(31.562 34.750) "GIOL" "lowerRight" "R90" "stick" 0.0625 nil)
schCreateWire(cv "route" "full" '((31.438 35.000) (31.438 34.250)) 0 0 0 nil nil)
schCreateWireLabel(cv nil '(31.438 34.750) "TRIG_CORE" "lowerRight" "R90" "stick" 0.0625 nil)
schCreatePin(cv nil "TRIG_CORE" "inputOutput" nil '(31.438 34.250) "R90")
schCreateWire(cv "route" "full" '((31.812 35.000) (31.812 34.250)) 0 0 0 nil nil)
schCreateWireLabel(cv nil '(31.812 34.750) "VIOL" "lowerRight" "R90" "stick" 0.0625 nil)
schCreateWire(cv "route" "full" '((31.938 35.000) (31.938 34.250)) 0 0 0 nil nil)
schCreateWireLabel(cv nil '(31.938 34.750) "GIOL" "lowerRight" "R90" "stick" 0.0625 nil)
schCreateWire(cv "route" "full" '((31.000 36.000) (31.000 36.750)) 0 0 0 nil nil)
schCreateWireLabel(cv nil '(31.000 36.250) "TRIG" "lowerLeft" "R90" "stick" 0.0625 nil)
schCreatePin(cv nil "TRIG" "inputOutput" nil '(31.000 36.750) "R270")
schCreateWire(cv "route" "full" '((31.312 35.000) (31.312 34.250)) 0 0 0 nil nil)
schCreateWireLabel(cv nil '(31.312 34.750) "POC" "lowerRight" "R90" "stick" 0.0625 nil)
schCreateWire(cv "route" "full" '((31.125 35.000) (31.125 34.250)) 0 0 0 nil nil)
schCreateWireLabel(cv nil '(31.125 34.750) "VIOL" "lowerRight" "R90" "stick" 0.0625 nil)
schCreateWire(cv "route" "full" '((30.938 35.000) (30.938 34.250)) 0 0 0 nil nil)
schCreateWireLabel(cv nil '(30.938 34.750) "GIOL" "lowerRight" "R90" "stick" 0.0625 nil)
schCreateWire(cv "route" "full" '((30.750 35.000) (30.750 34.250)) 0 0 0 nil nil)
schCreateWireLabel(cv nil '(30.750 34.750) "VIOH" "lowerRight" "R90" "stick" 0.0625 nil)
schCreateWire(cv "route" "full" '((30.375 35.000) (30.375 34.250)) 0 0 0 nil nil)
schCreateWireLabel(cv nil '(30.375 34.750) "GIOH" "lowerRight" "R90" "stick" 0.0625 nil)
dbCreateInst(cv pddw16sdgz_v_gMaster "SDO_top15" '(29.6875 36.0) "R180")
schCreateWire(cv "route" "full" '((29.562 35.000) (29.562 34.250)) 0 0 0 nil nil)
schCreateWireLabel(cv nil '(29.562 34.750) "VIOL" "lowerRight" "R90" "stick" 0.0625 nil)
noConnMaster = dbOpenCellView("basic" "noConn" "symbol")
schCreateWire(cv "route" "full" '((29.438 35.000) (29.438 34.250)) 0 0 0 nil nil)
dbCreateInst(cv noConnMaster "noConn_SDO_top15_C" '(29.438 34.250) "R0")
schCreateWire(cv "route" "full" '((29.812 35.000) (29.812 34.250)) 0 0 0 nil nil)
schCreateWireLabel(cv nil '(29.812 34.750) "GIOL" "lowerRight" "R90" "stick" 0.0625 nil)
schCreateWire(cv "route" "full" '((29.938 35.000) (29.938 34.250)) 0 0 0 nil nil)
schCreateWireLabel(cv nil '(29.938 34.750) "SDO_CORE" "lowerRight" "R90" "stick" 0.0625 nil)
schCreatePin(cv nil "SDO_CORE" "inputOutput" nil '(29.938 34.250) "R90")
schCreateWire(cv "route" "full" '((29.000 36.000) (29.000 36.750)) 0 0 0 nil nil)
schCreateWireLabel(cv nil '(29.000 36.250) "SDO" "lowerLeft" "R90" "stick" 0.0625 nil)
schCreatePin(cv nil "SDO" "inputOutput" nil '(29.000 36.750) "R270")
schCreateWire(cv "route" "full" '((29.312 35.000) (29.312 34.250)) 0 0 0 nil nil)
schCreateWireLabel(cv nil '(29.312 34.750) "POC" "lowerRight" "R90" "stick" 0.0625 nil)
schCreateWire(cv "route" "full" '((29.125 35.000) (29.125 34.250)) 0 0 0 nil nil)
schCreateWireLabel(cv nil '(29.125 34.750) "VIOL" "lowerRight" "R90" "stick" 0.0625 nil)
schCreateWire(cv "route" "full" '((28.938 35.000) (28.938 34.250)) 0 0 0 nil nil)
schCreateWireLabel(cv nil '(28.938 34.750) "GIOL" "lowerRight" "R90" "stick" 0.0625 nil)
schCreateWire(cv "route" "full" '((28.750 35.000) (28.750 34.250)) 0 0 0 nil nil)
schCreateWireLabel(cv nil '(28.750 34.750) "VIOH" "lowerRight" "R90" "stick" 0.0625 nil)
schCreateWire(cv "route" "full" '((28.375 35.000) (28.375 34.250)) 0 0 0 nil nil)
schCreateWireLabel(cv nil '(28.375 34.750) "GIOH" "lowerRight" "R90" "stick" 0.0625 nil)
dbCreateInst(cv pddw16sdgz_v_gMaster "CLKO_top16" '(27.6875 36.0) "R180")
schCreateWire(cv "route" "full" '((27.562 35.000) (27.562 34.250)) 0 0 0 nil nil)
schCreateWireLabel(cv nil '(27.562 34.750) "GIOL" "lowerRight" "R90" "stick" 0.0625 nil)
schCreateWire(cv "route" "full" '((27.438 35.000) (27.438 34.250)) 0 0 0 nil nil)
schCreateWireLabel(cv nil '(27.438 34.750) "CLKO_CORE" "lowerRight" "R90" "stick" 0.0625 nil)
schCreatePin(cv nil "CLKO_CORE" "inputOutput" nil '(27.438 34.250) "R90")
schCreateWire(cv "route" "full" '((27.812 35.000) (27.812 34.250)) 0 0 0 nil nil)
schCreateWireLabel(cv nil '(27.812 34.750) "VIOL" "lowerRight" "R90" "stick" 0.0625 nil)
schCreateWire(cv "route" "full" '((27.938 35.000) (27.938 34.250)) 0 0 0 nil nil)
schCreateWireLabel(cv nil '(27.938 34.750) "GIOL" "lowerRight" "R90" "stick" 0.0625 nil)
schCreateWire(cv "route" "full" '((27.000 36.000) (27.000 36.750)) 0 0 0 nil nil)
schCreateWireLabel(cv nil '(27.000 36.250) "CLKO" "lowerLeft" "R90" "stick" 0.0625 nil)
schCreatePin(cv nil "CLKO" "inputOutput" nil '(27.000 36.750) "R270")
schCreateWire(cv "route" "full" '((27.312 35.000) (27.312 34.250)) 0 0 0 nil nil)
schCreateWireLabel(cv nil '(27.312 34.750) "POC" "lowerRight" "R90" "stick" 0.0625 nil)
schCreateWire(cv "route" "full" '((27.125 35.000) (27.125 34.250)) 0 0 0 nil nil)
schCreateWireLabel(cv nil '(27.125 34.750) "VIOL" "lowerRight" "R90" "stick" 0.0625 nil)
schCreateWire(cv "route" "full" '((26.938 35.000) (26.938 34.250)) 0 0 0 nil nil)
schCreateWireLabel(cv nil '(26.938 34.750) "GIOL" "lowerRight" "R90" "stick" 0.0625 nil)
schCreateWire(cv "route" "full" '((26.750 35.000) (26.750 34.250)) 0 0 0 nil nil)
schCreateWireLabel(cv nil '(26.750 34.750) "VIOH" "lowerRight" "R90" "stick" 0.0625 nil)
schCreateWire(cv "route" "full" '((26.375 35.000) (26.375 34.250)) 0 0 0 nil nil)
schCreateWireLabel(cv nil '(26.375 34.750) "GIOH" "lowerRight" "R90" "stick" 0.0625 nil)
dbCreateInst(cv pddw16sdgz_v_gMaster "D_0_top17" '(25.6875 36.0) "R180")
schCreateWire(cv "route" "full" '((25.562 35.000) (25.562 34.250)) 0 0 0 nil nil)
schCreateWireLabel(cv nil '(25.562 34.750) "VIOL" "lowerRight" "R90" "stick" 0.0625 nil)
schCreateWire(cv "route" "full" '((25.438 35.000) (25.438 34.250)) 0 0 0 nil nil)
dbCreateInst(cv noConnMaster "noConn_D_0_top17_C" '(25.438 34.250) "R0")
schCreateWire(cv "route" "full" '((25.812 35.000) (25.812 34.250)) 0 0 0 nil nil)
schCreateWireLabel(cv nil '(25.812 34.750) "GIOL" "lowerRight" "R90" "stick" 0.0625 nil)
schCreateWire(cv "route" "full" '((25.938 35.000) (25.938 34.250)) 0 0 0 nil nil)
schCreateWireLabel(cv nil '(25.938 34.750) "D_CORE<0>" "lowerRight" "R90" "stick" 0.0625 nil)
schCreatePin(cv nil "D_CORE<0>" "inputOutput" nil '(25.938 34.250) "R90")
schCreateWire(cv "route" "full" '((25.000 36.000) (25.000 36.750)) 0 0 0 nil nil)
schCreateWireLabel(cv nil '(25.000 36.250) "D<0>" "lowerLeft" "R90" "stick" 0.0625 nil)
schCreatePin(cv nil "D<0>" "inputOutput" nil '(25.000 36.750) "R270")
schCreateWire(cv "route" "full" '((25.312 35.000) (25.312 34.250)) 0 0 0 nil nil)
schCreateWireLabel(cv nil '(25.312 34.750) "POC" "lowerRight" "R90" "stick" 0.0625 nil)
schCreateWire(cv "route" "full" '((25.125 35.000) (25.125 34.250)) 0 0 0 nil nil)
schCreateWireLabel(cv nil '(25.125 34.750) "VIOL" "lowerRight" "R90" "stick" 0.0625 nil)
schCreateWire(cv "route" "full" '((24.938 35.000) (24.938 34.250)) 0 0 0 nil nil)
schCreateWireLabel(cv nil '(24.938 34.750) "GIOL" "lowerRight" "R90" "stick" 0.0625 nil)
schCreateWire(cv "route" "full" '((24.750 35.000) (24.750 34.250)) 0 0 0 nil nil)
schCreateWireLabel(cv nil '(24.750 34.750) "VIOH" "lowerRight" "R90" "stick" 0.0625 nil)
schCreateWire(cv "route" "full" '((24.375 35.000) (24.375 34.250)) 0 0 0 nil nil)
schCreateWireLabel(cv nil '(24.375 34.750) "GIOH" "lowerRight" "R90" "stick" 0.0625 nil)
dbCreateInst(cv pddw16sdgz_v_gMaster "D_1_top18" '(23.6875 36.0) "R180")
schCreateWire(cv "route" "full" '((23.562 35.000) (23.562 34.250)) 0 0 0 nil nil)
schCreateWireLabel(cv nil '(23.562 34.750) "VIOL" "lowerRight" "R90" "stick" 0.0625 nil)
schCreateWire(cv "route" "full" '((23.438 35.000) (23.438 34.250)) 0 0 0 nil nil)
dbCreateInst(cv noConnMaster "noConn_D_1_top18_C" '(23.438 34.250) "R0")
schCreateWire(cv "route" "full" '((23.812 35.000) (23.812 34.250)) 0 0 0 nil nil)
schCreateWireLabel(cv nil '(23.812 34.750) "GIOL" "lowerRight" "R90" "stick" 0.0625 nil)
schCreateWire(cv "route" "full" '((23.938 35.000) (23.938 34.250)) 0 0 0 nil nil)
schCreateWireLabel(cv nil '(23.938 34.750) "D_CORE<1>" "lowerRight" "R90" "stick" 0.0625 nil)
schCreatePin(cv nil "D_CORE<1>" "inputOutput" nil '(23.938 34.250) "R90")
schCreateWire(cv "route" "full" '((23.000 36.000) (23.000 36.750)) 0 0 0 nil nil)
schCreateWireLabel(cv nil '(23.000 36.250) "D<1>" "lowerLeft" "R90" "stick" 0.0625 nil)
schCreatePin(cv nil "D<1>" "inputOutput" nil '(23.000 36.750) "R270")
schCreateWire(cv "route" "full" '((23.312 35.000) (23.312 34.250)) 0 0 0 nil nil)
schCreateWireLabel(cv nil '(23.312 34.750) "POC" "lowerRight" "R90" "stick" 0.0625 nil)
schCreateWire(cv "route" "full" '((23.125 35.000) (23.125 34.250)) 0 0 0 nil nil)
schCreateWireLabel(cv nil '(23.125 34.750) "VIOL" "lowerRight" "R90" "stick" 0.0625 nil)
schCreateWire(cv "route" "full" '((22.938 35.000) (22.938 34.250)) 0 0 0 nil nil)
schCreateWireLabel(cv nil '(22.938 34.750) "GIOL" "lowerRight" "R90" "stick" 0.0625 nil)
schCreateWire(cv "route" "full" '((22.750 35.000) (22.750 34.250)) 0 0 0 nil nil)
schCreateWireLabel(cv nil '(22.750 34.750) "VIOH" "lowerRight" "R90" "stick" 0.0625 nil)
schCreateWire(cv "route" "full" '((22.375 35.000) (22.375 34.250)) 0 0 0 nil nil)
schCreateWireLabel(cv nil '(22.375 34.750) "GIOH" "lowerRight" "R90" "stick" 0.0625 nil)
dbCreateInst(cv pddw16sdgz_v_gMaster "D_2_top19" '(21.6875 36.0) "R180")
schCreateWire(cv "route" "full" '((21.562 35.000) (21.562 34.250)) 0 0 0 nil nil)
schCreateWireLabel(cv nil '(21.562 34.750) "VIOL" "lowerRight" "R90" "stick" 0.0625 nil)
schCreateWire(cv "route" "full" '((21.438 35.000) (21.438 34.250)) 0 0 0 nil nil)
dbCreateInst(cv noConnMaster "noConn_D_2_top19_C" '(21.438 34.250) "R0")
schCreateWire(cv "route" "full" '((21.812 35.000) (21.812 34.250)) 0 0 0 nil nil)
schCreateWireLabel(cv nil '(21.812 34.750) "GIOL" "lowerRight" "R90" "stick" 0.0625 nil)
schCreateWire(cv "route" "full" '((21.938 35.000) (21.938 34.250)) 0 0 0 nil nil)
schCreateWireLabel(cv nil '(21.938 34.750) "D_CORE<2>" "lowerRight" "R90" "stick" 0.0625 nil)
schCreatePin(cv nil "D_CORE<2>" "inputOutput" nil '(21.938 34.250) "R90")
schCreateWire(cv "route" "full" '((21.000 36.000) (21.000 36.750)) 0 0 0 nil nil)
schCreateWireLabel(cv nil '(21.000 36.250) "D<2>" "lowerLeft" "R90" "stick" 0.0625 nil)
schCreatePin(cv nil "D<2>" "inputOutput" nil '(21.000 36.750) "R270")
schCreateWire(cv "route" "full" '((21.312 35.000) (21.312 34.250)) 0 0 0 nil nil)
schCreateWireLabel(cv nil '(21.312 34.750) "POC" "lowerRight" "R90" "stick" 0.0625 nil)
schCreateWire(cv "route" "full" '((21.125 35.000) (21.125 34.250)) 0 0 0 nil nil)
schCreateWireLabel(cv nil '(21.125 34.750) "VIOL" "lowerRight" "R90" "stick" 0.0625 nil)
schCreateWire(cv "route" "full" '((20.938 35.000) (20.938 34.250)) 0 0 0 nil nil)
schCreateWireLabel(cv nil '(20.938 34.750) "GIOL" "lowerRight" "R90" "stick" 0.0625 nil)
schCreateWire(cv "route" "full" '((20.750 35.000) (20.750 34.250)) 0 0 0 nil nil)
schCreateWireLabel(cv nil '(20.750 34.750) "VIOH" "lowerRight" "R90" "stick" 0.0625 nil)
schCreateWire(cv "route" "full" '((20.375 35.000) (20.375 34.250)) 0 0 0 nil nil)
schCreateWireLabel(cv nil '(20.375 34.750) "GIOH" "lowerRight" "R90" "stick" 0.0625 nil)
dbCreateInst(cv pddw16sdgz_v_gMaster "D_3_top20" '(19.6875 36.0) "R180")
schCreateWire(cv "route" "full" '((19.562 35.000) (19.562 34.250)) 0 0 0 nil nil)
schCreateWireLabel(cv nil '(19.562 34.750) "VIOL" "lowerRight" "R90" "stick" 0.0625 nil)
schCreateWire(cv "route" "full" '((19.438 35.000) (19.438 34.250)) 0 0 0 nil nil)
dbCreateInst(cv noConnMaster "noConn_D_3_top20_C" '(19.438 34.250) "R0")
schCreateWire(cv "route" "full" '((19.812 35.000) (19.812 34.250)) 0 0 0 nil nil)
schCreateWireLabel(cv nil '(19.812 34.750) "GIOL" "lowerRight" "R90" "stick" 0.0625 nil)
schCreateWire(cv "route" "full" '((19.938 35.000) (19.938 34.250)) 0 0 0 nil nil)
schCreateWireLabel(cv nil '(19.938 34.750) "D_CORE<3>" "lowerRight" "R90" "stick" 0.0625 nil)
schCreatePin(cv nil "D_CORE<3>" "inputOutput" nil '(19.938 34.250) "R90")
schCreateWire(cv "route" "full" '((19.000 36.000) (19.000 36.750)) 0 0 0 nil nil)
schCreateWireLabel(cv nil '(19.000 36.250) "D<3>" "lowerLeft" "R90" "stick" 0.0625 nil)
schCreatePin(cv nil "D<3>" "inputOutput" nil '(19.000 36.750) "R270")
schCreateWire(cv "route" "full" '((19.312 35.000) (19.312 34.250)) 0 0 0 nil nil)
schCreateWireLabel(cv nil '(19.312 34.750) "POC" "lowerRight" "R90" "stick" 0.0625 nil)
schCreateWire(cv "route" "full" '((19.125 35.000) (19.125 34.250)) 0 0 0 nil nil)
schCreateWireLabel(cv nil '(19.125 34.750) "VIOL" "lowerRight" "R90" "stick" 0.0625 nil)
schCreateWire(cv "route" "full" '((18.938 35.000) (18.938 34.250)) 0 0 0 nil nil)
schCreateWireLabel(cv nil '(18.938 34.750) "GIOL" "lowerRight" "R90" "stick" 0.0625 nil)
schCreateWire(cv "route" "full" '((18.750 35.000) (18.750 34.250)) 0 0 0 nil nil)
schCreateWireLabel(cv nil '(18.750 34.750) "VIOH" "lowerRight" "R90" "stick" 0.0625 nil)
schCreateWire(cv "route" "full" '((18.375 35.000) (18.375 34.250)) 0 0 0 nil nil)
schCreateWireLabel(cv nil '(18.375 34.750) "GIOH" "lowerRight" "R90" "stick" 0.0625 nil)
dbCreateInst(cv pddw16sdgz_v_gMaster "D_4_top21" '(17.6875 36.0) "R180")
schCreateWire(cv "route" "full" '((17.562 35.000) (17.562 34.250)) 0 0 0 nil nil)
schCreateWireLabel(cv nil '(17.562 34.750) "VIOL" "lowerRight" "R90" "stick" 0.0625 nil)
schCreateWire(cv "route" "full" '((17.438 35.000) (17.438 34.250)) 0 0 0 nil nil)
dbCreateInst(cv noConnMaster "noConn_D_4_top21_C" '(17.438 34.250) "R0")
schCreateWire(cv "route" "full" '((17.812 35.000) (17.812 34.250)) 0 0 0 nil nil)
schCreateWireLabel(cv nil '(17.812 34.750) "GIOL" "lowerRight" "R90" "stick" 0.0625 nil)
schCreateWire(cv "route" "full" '((17.938 35.000) (17.938 34.250)) 0 0 0 nil nil)
schCreateWireLabel(cv nil '(17.938 34.750) "D_CORE<4>" "lowerRight" "R90" "stick" 0.0625 nil)
schCreatePin(cv nil "D_CORE<4>" "inputOutput" nil '(17.938 34.250) "R90")
schCreateWire(cv "route" "full" '((17.000 36.000) (17.000 36.750)) 0 0 0 nil nil)
schCreateWireLabel(cv nil '(17.000 36.250) "D<4>" "lowerLeft" "R90" "stick" 0.0625 nil)
schCreatePin(cv nil "D<4>" "inputOutput" nil '(17.000 36.750) "R270")
schCreateWire(cv "route" "full" '((17.312 35.000) (17.312 34.250)) 0 0 0 nil nil)
schCreateWireLabel(cv nil '(17.312 34.750) "POC" "lowerRight" "R90" "stick" 0.0625 nil)
schCreateWire(cv "route" "full" '((17.125 35.000) (17.125 34.250)) 0 0 0 nil nil)
schCreateWireLabel(cv nil '(17.125 34.750) "VIOL" "lowerRight" "R90" "stick" 0.0625 nil)
schCreateWire(cv "route" "full" '((16.938 35.000) (16.938 34.250)) 0 0 0 nil nil)
schCreateWireLabel(cv nil '(16.938 34.750) "GIOL" "lowerRight" "R90" "stick" 0.0625 nil)
schCreateWire(cv "route" "full" '((16.750 35.000) (16.750 34.250)) 0 0 0 nil nil)
schCreateWireLabel(cv nil '(16.750 34.750) "VIOH" "lowerRight" "R90" "stick" 0.0625 nil)
schCreateWire(cv "route" "full" '((16.375 35.000) (16.375 34.250)) 0 0 0 nil nil)
schCreateWireLabel(cv nil '(16.375 34.750) "GIOH" "lowerRight" "R90" "stick" 0.0625 nil)
dbCreateInst(cv pddw16sdgz_v_gMaster "D_5_top22" '(15.6875 36.0) "R180")
schCreateWire(cv "route" "full" '((15.562 35.000) (15.562 34.250)) 0 0 0 nil nil)
schCreateWireLabel(cv nil '(15.562 34.750) "VIOL" "lowerRight" "R90" "stick" 0.0625 nil)
schCreateWire(cv "route" "full" '((15.438 35.000) (15.438 34.250)) 0 0 0 nil nil)
dbCreateInst(cv noConnMaster "noConn_D_5_top22_C" '(15.438 34.250) "R0")
schCreateWire(cv "route" "full" '((15.812 35.000) (15.812 34.250)) 0 0 0 nil nil)
schCreateWireLabel(cv nil '(15.812 34.750) "GIOL" "lowerRight" "R90" "stick" 0.0625 nil)
schCreateWire(cv "route" "full" '((15.938 35.000) (15.938 34.250)) 0 0 0 nil nil)
schCreateWireLabel(cv nil '(15.938 34.750) "D_CORE<5>" "lowerRight" "R90" "stick" 0.0625 nil)
schCreatePin(cv nil "D_CORE<5>" "inputOutput" nil '(15.938 34.250) "R90")
schCreateWire(cv "route" "full" '((14.999 36.000) (14.999 36.750)) 0 0 0 nil nil)
schCreateWireLabel(cv nil '(14.999 36.250) "D<5>" "lowerLeft" "R90" "stick" 0.0625 nil)
schCreatePin(cv nil "D<5>" "inputOutput" nil '(14.999 36.750) "R270")
schCreateWire(cv "route" "full" '((15.312 35.000) (15.312 34.250)) 0 0 0 nil nil)
schCreateWireLabel(cv nil '(15.312 34.750) "POC" "lowerRight" "R90" "stick" 0.0625 nil)
schCreateWire(cv "route" "full" '((15.126 35.000) (15.126 34.250)) 0 0 0 nil nil)
schCreateWireLabel(cv nil '(15.126 34.750) "VIOL" "lowerRight" "R90" "stick" 0.0625 nil)
schCreateWire(cv "route" "full" '((14.938 35.000) (14.938 34.250)) 0 0 0 nil nil)
schCreateWireLabel(cv nil '(14.938 34.750) "GIOL" "lowerRight" "R90" "stick" 0.0625 nil)
schCreateWire(cv "route" "full" '((14.749 35.000) (14.749 34.250)) 0 0 0 nil nil)
schCreateWireLabel(cv nil '(14.749 34.750) "VIOH" "lowerRight" "R90" "stick" 0.0625 nil)
schCreateWire(cv "route" "full" '((14.376 35.000) (14.376 34.250)) 0 0 0 nil nil)
schCreateWireLabel(cv nil '(14.376 34.750) "GIOH" "lowerRight" "R90" "stick" 0.0625 nil)
dbCreateInst(cv pddw16sdgz_v_gMaster "FLAG_top23" '(13.6875 36.0) "R180")
schCreateWire(cv "route" "full" '((13.562 35.000) (13.562 34.250)) 0 0 0 nil nil)
schCreateWireLabel(cv nil '(13.562 34.750) "VIOL" "lowerRight" "R90" "stick" 0.0625 nil)
schCreateWire(cv "route" "full" '((13.438 35.000) (13.438 34.250)) 0 0 0 nil nil)
dbCreateInst(cv noConnMaster "noConn_FLAG_top23_C" '(13.438 34.250) "R0")
schCreateWire(cv "route" "full" '((13.812 35.000) (13.812 34.250)) 0 0 0 nil nil)
schCreateWireLabel(cv nil '(13.812 34.750) "GIOL" "lowerRight" "R90" "stick" 0.0625 nil)
schCreateWire(cv "route" "full" '((13.938 35.000) (13.938 34.250)) 0 0 0 nil nil)
schCreateWireLabel(cv nil '(13.938 34.750) "FLAG_CORE" "lowerRight" "R90" "stick" 0.0625 nil)
schCreatePin(cv nil "FLAG_CORE" "inputOutput" nil '(13.938 34.250) "R90")
schCreateWire(cv "route" "full" '((12.999 36.000) (12.999 36.750)) 0 0 0 nil nil)
schCreateWireLabel(cv nil '(12.999 36.250) "FLAG" "lowerLeft" "R90" "stick" 0.0625 nil)
schCreatePin(cv nil "FLAG" "inputOutput" nil '(12.999 36.750) "R270")
schCreateWire(cv "route" "full" '((13.312 35.000) (13.312 34.250)) 0 0 0 nil nil)
schCreateWireLabel(cv nil '(13.312 34.750) "POC" "lowerRight" "R90" "stick" 0.0625 nil)
schCreateWire(cv "route" "full" '((13.126 35.000) (13.126 34.250)) 0 0 0 nil nil)
schCreateWireLabel(cv nil '(13.126 34.750) "VIOL" "lowerRight" "R90" "stick" 0.0625 nil)
schCreateWire(cv "route" "full" '((12.938 35.000) (12.938 34.250)) 0 0 0 nil nil)
schCreateWireLabel(cv nil '(12.938 34.750) "GIOL" "lowerRight" "R90" "stick" 0.0625 nil)
schCreateWire(cv "route" "full" '((12.749 35.000) (12.749 34.250)) 0 0 0 nil nil)
schCreateWireLabel(cv nil '(12.749 34.750) "VIOH" "lowerRight" "R90" "stick" 0.0625 nil)
schCreateWire(cv "route" "full" '((12.376 35.000) (12.376 34.250)) 0 0 0 nil nil)
schCreateWireLabel(cv nil '(12.376 34.750) "GIOH" "lowerRight" "R90" "stick" 0.0625 nil)
dbCreateInst(cv pddw16sdgz_v_gMaster "RST_top24" '(11.6875 36.0) "R180")
schCreateWire(cv "route" "full" '((11.562 35.000) (11.562 34.250)) 0 0 0 nil nil)
schCreateWireLabel(cv nil '(11.562 34.750) "GIOL" "lowerRight" "R90" "stick" 0.0625 nil)
schCreateWire(cv "route" "full" '((11.438 35.000) (11.438 34.250)) 0 0 0 nil nil)
schCreateWireLabel(cv nil '(11.438 34.750) "RST_CORE" "lowerRight" "R90" "stick" 0.0625 nil)
schCreatePin(cv nil "RST_CORE" "inputOutput" nil '(11.438 34.250) "R90")
schCreateWire(cv "route" "full" '((11.812 35.000) (11.812 34.250)) 0 0 0 nil nil)
schCreateWireLabel(cv nil '(11.812 34.750) "VIOL" "lowerRight" "R90" "stick" 0.0625 nil)
schCreateWire(cv "route" "full" '((11.938 35.000) (11.938 34.250)) 0 0 0 nil nil)
schCreateWireLabel(cv nil '(11.938 34.750) "GIOL" "lowerRight" "R90" "stick" 0.0625 nil)
schCreateWire(cv "route" "full" '((10.999 36.000) (10.999 36.750)) 0 0 0 nil nil)
schCreateWireLabel(cv nil '(10.999 36.250) "RST" "lowerLeft" "R90" "stick" 0.0625 nil)
schCreatePin(cv nil "RST" "inputOutput" nil '(10.999 36.750) "R270")
schCreateWire(cv "route" "full" '((11.312 35.000) (11.312 34.250)) 0 0 0 nil nil)
schCreateWireLabel(cv nil '(11.312 34.750) "POC" "lowerRight" "R90" "stick" 0.0625 nil)
schCreateWire(cv "route" "full" '((11.126 35.000) (11.126 34.250)) 0 0 0 nil nil)
schCreateWireLabel(cv nil '(11.126 34.750) "VIOL" "lowerRight" "R90" "stick" 0.0625 nil)
schCreateWire(cv "route" "full" '((10.938 35.000) (10.938 34.250)) 0 0 0 nil nil)
schCreateWireLabel(cv nil '(10.938 34.750) "GIOL" "lowerRight" "R90" "stick" 0.0625 nil)
schCreateWire(cv "route" "full" '((10.749 35.000) (10.749 34.250)) 0 0 0 nil nil)
schCreateWireLabel(cv nil '(10.749 34.750) "VIOH" "lowerRight" "R90" "stick" 0.0625 nil)
schCreateWire(cv "route" "full" '((10.376 35.000) (10.376 34.250)) 0 0 0 nil nil)
schCreateWireLabel(cv nil '(10.376 34.750) "GIOH" "lowerRight" "R90" "stick" 0.0625 nil)
dbCreateInst(cv pddw16sdgz_v_gMaster "SDI_top25" '(9.6875 36.0) "R180")
schCreateWire(cv "route" "full" '((9.562 35.000) (9.562 34.250)) 0 0 0 nil nil)
schCreateWireLabel(cv nil '(9.562 34.750) "GIOL" "lowerRight" "R90" "stick" 0.0625 nil)
schCreateWire(cv "route" "full" '((9.438 35.000) (9.438 34.250)) 0 0 0 nil nil)
schCreateWireLabel(cv nil '(9.438 34.750) "SDI_CORE" "lowerRight" "R90" "stick" 0.0625 nil)
schCreatePin(cv nil "SDI_CORE" "inputOutput" nil '(9.438 34.250) "R90")
schCreateWire(cv "route" "full" '((9.812 35.000) (9.812 34.250)) 0 0 0 nil nil)
schCreateWireLabel(cv nil '(9.812 34.750) "VIOL" "lowerRight" "R90" "stick" 0.0625 nil)
schCreateWire(cv "route" "full" '((9.938 35.000) (9.938 34.250)) 0 0 0 nil nil)
schCreateWireLabel(cv nil '(9.938 34.750) "GIOL" "lowerRight" "R90" "stick" 0.0625 nil)
schCreateWire(cv "route" "full" '((8.999 36.000) (8.999 36.750)) 0 0 0 nil nil)
schCreateWireLabel(cv nil '(8.999 36.250) "SDI" "lowerLeft" "R90" "stick" 0.0625 nil)
schCreatePin(cv nil "SDI" "inputOutput" nil '(8.999 36.750) "R270")
schCreateWire(cv "route" "full" '((9.312 35.000) (9.312 34.250)) 0 0 0 nil nil)
schCreateWireLabel(cv nil '(9.312 34.750) "POC" "lowerRight" "R90" "stick" 0.0625 nil)
schCreateWire(cv "route" "full" '((9.126 35.000) (9.126 34.250)) 0 0 0 nil nil)
schCreateWireLabel(cv nil '(9.126 34.750) "VIOL" "lowerRight" "R90" "stick" 0.0625 nil)
schCreateWire(cv "route" "full" '((8.938 35.000) (8.938 34.250)) 0 0 0 nil nil)
schCreateWireLabel(cv nil '(8.938 34.750) "GIOL" "lowerRight" "R90" "stick" 0.0625 nil)
schCreateWire(cv "route" "full" '((8.749 35.000) (8.749 34.250)) 0 0 0 nil nil)
schCreateWireLabel(cv nil '(8.749 34.750) "VIOH" "lowerRight" "R90" "stick" 0.0625 nil)
schCreateWire(cv "route" "full" '((8.376 35.000) (8.376 34.250)) 0 0 0 nil nil)
schCreateWireLabel(cv nil '(8.376 34.750) "GIOH" "lowerRight" "R90" "stick" 0.0625 nil)
dbCreateInst(cv pdb3ac_v_gMaster "FVDD_top26" '(6.8125 36.0) "R180")
schCreateWire(cv "route" "full" '((7.000 36.000) (7.000 36.750)) 0 0 0 nil nil)
schCreateWireLabel(cv nil '(7.000 36.250) "FVDD" "lowerLeft" "R90" "stick" 0.0625 nil)
schCreatePin(cv nil "FVDD" "inputOutput" nil '(7.000 36.750) "R270")
schCreateWire(cv "route" "full" '((7.062 35.125) (7.062 34.375)) 0 0 0 nil nil)
schCreateWireLabel(cv nil '(7.062 34.875) "VSSCAL" "lowerRight" "R90" "stick" 0.0625 nil)
schCreateWire(cv "route" "full" '((6.688 35.125) (6.688 34.375)) 0 0 0 nil nil)
schCreateWireLabel(cv nil '(6.688 34.875) "GIOL" "lowerRight" "R90" "stick" 0.0625 nil)
schCreateWire(cv "route" "full" '((7.438 35.125) (7.438 34.375)) 0 0 0 nil nil)
schCreateWireLabel(cv nil '(7.438 34.875) "VDDCAL" "lowerRight" "R90" "stick" 0.0625 nil)
dbCreateInst(cv pdb3ac_v_gMaster "FVDDH_top27" '(4.8125 36.0) "R180")
schCreateWire(cv "route" "full" '((5.000 36.000) (5.000 36.750)) 0 0 0 nil nil)
schCreateWireLabel(cv nil '(5.000 36.250) "FVDDH" "lowerLeft" "R90" "stick" 0.0625 nil)
schCreatePin(cv nil "FVDDH" "inputOutput" nil '(5.000 36.750) "R270")
schCreateWire(cv "route" "full" '((5.062 35.125) (5.062 34.375)) 0 0 0 nil nil)
schCreateWireLabel(cv nil '(5.062 34.875) "VSSCAL" "lowerRight" "R90" "stick" 0.0625 nil)
schCreateWire(cv "route" "full" '((4.688 35.125) (4.688 34.375)) 0 0 0 nil nil)
schCreateWireLabel(cv nil '(4.688 34.875) "GIOL" "lowerRight" "R90" "stick" 0.0625 nil)
schCreateWire(cv "route" "full" '((5.438 35.125) (5.438 34.375)) 0 0 0 nil nil)
schCreateWireLabel(cv nil '(5.438 34.875) "VDDCAL" "lowerRight" "R90" "stick" 0.0625 nil)
dbCreateInst(cv pdb3ac_v_gMaster "FVSS_top28" '(2.8125 36.0) "R180")
schCreateWire(cv "route" "full" '((3.001 36.000) (3.001 36.750)) 0 0 0 nil nil)
schCreateWireLabel(cv nil '(3.001 36.250) "FVSS" "lowerLeft" "R90" "stick" 0.0625 nil)
schCreatePin(cv nil "FVSS" "inputOutput" nil '(3.001 36.750) "R270")
schCreateWire(cv "route" "full" '((3.062 35.125) (3.062 34.375)) 0 0 0 nil nil)
schCreateWireLabel(cv nil '(3.062 34.875) "VSSCAL" "lowerRight" "R90" "stick" 0.0625 nil)
schCreateWire(cv "route" "full" '((2.688 35.125) (2.688 34.375)) 0 0 0 nil nil)
schCreateWireLabel(cv nil '(2.688 34.875) "GIOL" "lowerRight" "R90" "stick" 0.0625 nil)
schCreateWire(cv "route" "full" '((3.438 35.125) (3.438 34.375)) 0 0 0 nil nil)
schCreateWireLabel(cv nil '(3.438 34.875) "VDDCAL" "lowerRight" "R90" "stick" 0.0625 nil)
schCheck(cv)
dbSave(cv)
t
